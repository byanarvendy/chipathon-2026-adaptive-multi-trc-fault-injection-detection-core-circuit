* NGSPICE file created from trc_top.ext - technology: gf180mcuD

* Black-box entry subcircuit for gf180mcu_fd_sc_mcu7t5v0__fillcap_64 abstract view
.subckt gf180mcu_fd_sc_mcu7t5v0__fillcap_64 VDD VNW VPW VSS
.ends

* Black-box entry subcircuit for gf180mcu_fd_sc_mcu7t5v0__fillcap_8 abstract view
.subckt gf180mcu_fd_sc_mcu7t5v0__fillcap_8 VDD VNW VPW VSS
.ends

* Black-box entry subcircuit for gf180mcu_fd_sc_mcu7t5v0__filltie abstract view
.subckt gf180mcu_fd_sc_mcu7t5v0__filltie VDD VSS
.ends

* Black-box entry subcircuit for gf180mcu_fd_sc_mcu7t5v0__fill_1 abstract view
.subckt gf180mcu_fd_sc_mcu7t5v0__fill_1 VDD VNW VPW VSS
.ends

* Black-box entry subcircuit for gf180mcu_fd_sc_mcu7t5v0__fillcap_32 abstract view
.subckt gf180mcu_fd_sc_mcu7t5v0__fillcap_32 VDD VNW VPW VSS
.ends

* Black-box entry subcircuit for gf180mcu_fd_sc_mcu7t5v0__mux2_2 abstract view
.subckt gf180mcu_fd_sc_mcu7t5v0__mux2_2 I0 I1 S Z VDD VNW VPW VSS
.ends

* Black-box entry subcircuit for gf180mcu_fd_sc_mcu7t5v0__oai31_1 abstract view
.subckt gf180mcu_fd_sc_mcu7t5v0__oai31_1 A1 A2 A3 B ZN VDD VNW VPW VSS
.ends

* Black-box entry subcircuit for gf180mcu_fd_sc_mcu7t5v0__and2_1 abstract view
.subckt gf180mcu_fd_sc_mcu7t5v0__and2_1 A1 A2 Z VDD VNW VPW VSS
.ends

* Black-box entry subcircuit for gf180mcu_fd_sc_mcu7t5v0__fillcap_4 abstract view
.subckt gf180mcu_fd_sc_mcu7t5v0__fillcap_4 VDD VNW VPW VSS
.ends

* Black-box entry subcircuit for gf180mcu_fd_sc_mcu7t5v0__fillcap_16 abstract view
.subckt gf180mcu_fd_sc_mcu7t5v0__fillcap_16 VDD VNW VPW VSS
.ends

* Black-box entry subcircuit for gf180mcu_fd_sc_mcu7t5v0__fill_2 abstract view
.subckt gf180mcu_fd_sc_mcu7t5v0__fill_2 VDD VNW VPW VSS
.ends

* Black-box entry subcircuit for gf180mcu_fd_sc_mcu7t5v0__inv_1 abstract view
.subckt gf180mcu_fd_sc_mcu7t5v0__inv_1 I ZN VDD VNW VPW VSS
.ends

* Black-box entry subcircuit for gf180mcu_fd_sc_mcu7t5v0__aoi22_1 abstract view
.subckt gf180mcu_fd_sc_mcu7t5v0__aoi22_1 A1 A2 B1 B2 ZN VDD VNW VPW VSS
.ends

* Black-box entry subcircuit for gf180mcu_fd_sc_mcu7t5v0__aoi21_1 abstract view
.subckt gf180mcu_fd_sc_mcu7t5v0__aoi21_1 A1 A2 B ZN VDD VNW VPW VSS
.ends

* Black-box entry subcircuit for gf180mcu_fd_sc_mcu7t5v0__clkinv_1 abstract view
.subckt gf180mcu_fd_sc_mcu7t5v0__clkinv_1 I ZN VDD VNW VPW VSS
.ends

* Black-box entry subcircuit for gf180mcu_fd_sc_mcu7t5v0__endcap abstract view
.subckt gf180mcu_fd_sc_mcu7t5v0__endcap VDD VSS
.ends

* Black-box entry subcircuit for gf180mcu_fd_sc_mcu7t5v0__dffrnq_1 abstract view
.subckt gf180mcu_fd_sc_mcu7t5v0__dffrnq_1 D RN CLK Q VDD VNW VPW VSS
.ends

* Black-box entry subcircuit for gf180mcu_fd_sc_mcu7t5v0__buf_3 abstract view
.subckt gf180mcu_fd_sc_mcu7t5v0__buf_3 I Z VDD VNW VPW VSS
.ends

* Black-box entry subcircuit for gf180mcu_fd_sc_mcu7t5v0__dlyc_1 abstract view
.subckt gf180mcu_fd_sc_mcu7t5v0__dlyc_1 I Z VDD VNW VPW VSS
.ends

* Black-box entry subcircuit for gf180mcu_fd_sc_mcu7t5v0__inv_2 abstract view
.subckt gf180mcu_fd_sc_mcu7t5v0__inv_2 I ZN VDD VNW VPW VSS
.ends

* Black-box entry subcircuit for gf180mcu_fd_sc_mcu7t5v0__tiel abstract view
.subckt gf180mcu_fd_sc_mcu7t5v0__tiel ZN VDD VNW VPW VSS
.ends

* Black-box entry subcircuit for gf180mcu_fd_sc_mcu7t5v0__dffsnq_1 abstract view
.subckt gf180mcu_fd_sc_mcu7t5v0__dffsnq_1 D SETN CLK Q VDD VNW VPW VSS
.ends

* Black-box entry subcircuit for gf180mcu_fd_sc_mcu7t5v0__nor3_1 abstract view
.subckt gf180mcu_fd_sc_mcu7t5v0__nor3_1 A1 A2 A3 ZN VDD VNW VPW VSS
.ends

* Black-box entry subcircuit for gf180mcu_fd_sc_mcu7t5v0__nor2_1 abstract view
.subckt gf180mcu_fd_sc_mcu7t5v0__nor2_1 A1 A2 ZN VDD VNW VPW VSS
.ends

* Black-box entry subcircuit for gf180mcu_fd_sc_mcu7t5v0__dffnrnq_1 abstract view
.subckt gf180mcu_fd_sc_mcu7t5v0__dffnrnq_1 D RN CLKN Q VDD VNW VPW VSS
.ends

* Black-box entry subcircuit for gf180mcu_fd_sc_mcu7t5v0__aoi211_1 abstract view
.subckt gf180mcu_fd_sc_mcu7t5v0__aoi211_1 A1 A2 B C ZN VDD VNW VPW VSS
.ends

* Black-box entry subcircuit for gf180mcu_fd_sc_mcu7t5v0__oai21_1 abstract view
.subckt gf180mcu_fd_sc_mcu7t5v0__oai21_1 A1 A2 B ZN VDD VNW VPW VSS
.ends

* Black-box entry subcircuit for gf180mcu_fd_sc_mcu7t5v0__buf_4 abstract view
.subckt gf180mcu_fd_sc_mcu7t5v0__buf_4 I Z VDD VNW VPW VSS
.ends

* Black-box entry subcircuit for gf180mcu_fd_sc_mcu7t5v0__nand2_1 abstract view
.subckt gf180mcu_fd_sc_mcu7t5v0__nand2_1 A1 A2 ZN VDD VNW VPW VSS
.ends

* Black-box entry subcircuit for gf180mcu_fd_sc_mcu7t5v0__and3_1 abstract view
.subckt gf180mcu_fd_sc_mcu7t5v0__and3_1 A1 A2 A3 Z VDD VNW VPW VSS
.ends

* Black-box entry subcircuit for gf180mcu_fd_sc_mcu7t5v0__xor2_1 abstract view
.subckt gf180mcu_fd_sc_mcu7t5v0__xor2_1 A1 A2 Z VDD VNW VPW VSS
.ends

* Black-box entry subcircuit for gf180mcu_fd_sc_mcu7t5v0__nand3_1 abstract view
.subckt gf180mcu_fd_sc_mcu7t5v0__nand3_1 A1 A2 A3 ZN VDD VNW VPW VSS
.ends

* Black-box entry subcircuit for gf180mcu_fd_sc_mcu7t5v0__buf_2 abstract view
.subckt gf180mcu_fd_sc_mcu7t5v0__buf_2 I Z VDD VNW VPW VSS
.ends

* Black-box entry subcircuit for gf180mcu_fd_sc_mcu7t5v0__clkbuf_16 abstract view
.subckt gf180mcu_fd_sc_mcu7t5v0__clkbuf_16 I Z VDD VNW VPW VSS
.ends

* Black-box entry subcircuit for gf180mcu_fd_sc_mcu7t5v0__clkbuf_3 abstract view
.subckt gf180mcu_fd_sc_mcu7t5v0__clkbuf_3 I Z VDD VNW VPW VSS
.ends

* Black-box entry subcircuit for gf180mcu_fd_sc_mcu7t5v0__clkbuf_2 abstract view
.subckt gf180mcu_fd_sc_mcu7t5v0__clkbuf_2 I Z VDD VNW VPW VSS
.ends

* Black-box entry subcircuit for gf180mcu_fd_sc_mcu7t5v0__or2_1 abstract view
.subckt gf180mcu_fd_sc_mcu7t5v0__or2_1 A1 A2 Z VDD VNW VPW VSS
.ends

* Black-box entry subcircuit for gf180mcu_fd_sc_mcu7t5v0__or3_1 abstract view
.subckt gf180mcu_fd_sc_mcu7t5v0__or3_1 A1 A2 A3 Z VDD VNW VPW VSS
.ends

* Black-box entry subcircuit for gf180mcu_fd_sc_mcu7t5v0__oai22_1 abstract view
.subckt gf180mcu_fd_sc_mcu7t5v0__oai22_1 A1 A2 B1 B2 ZN VDD VNW VPW VSS
.ends

* Black-box entry subcircuit for gf180mcu_fd_sc_mcu7t5v0__dlyb_1 abstract view
.subckt gf180mcu_fd_sc_mcu7t5v0__dlyb_1 I Z VDD VNW VPW VSS
.ends

* Black-box entry subcircuit for gf180mcu_fd_sc_mcu7t5v0__clkinv_2 abstract view
.subckt gf180mcu_fd_sc_mcu7t5v0__clkinv_2 I ZN VDD VNW VPW VSS
.ends

* Black-box entry subcircuit for gf180mcu_fd_sc_mcu7t5v0__nand4_1 abstract view
.subckt gf180mcu_fd_sc_mcu7t5v0__nand4_1 A1 A2 A3 A4 ZN VDD VNW VPW VSS
.ends

* Black-box entry subcircuit for gf180mcu_fd_sc_mcu7t5v0__dffrnq_2 abstract view
.subckt gf180mcu_fd_sc_mcu7t5v0__dffrnq_2 D RN CLK Q VDD VNW VPW VSS
.ends

* Black-box entry subcircuit for gf180mcu_fd_sc_mcu7t5v0__buf_1 abstract view
.subckt gf180mcu_fd_sc_mcu7t5v0__buf_1 I Z VDD VNW VPW VSS
.ends

* Black-box entry subcircuit for gf180mcu_fd_sc_mcu7t5v0__xor3_1 abstract view
.subckt gf180mcu_fd_sc_mcu7t5v0__xor3_1 A1 A2 A3 Z VDD VNW VPW VSS
.ends

* Black-box entry subcircuit for gf180mcu_fd_sc_mcu7t5v0__mux4_1 abstract view
.subckt gf180mcu_fd_sc_mcu7t5v0__mux4_1 I0 I1 I2 I3 S0 S1 Z VDD VNW VPW VSS
.ends

* Black-box entry subcircuit for gf180mcu_fd_sc_mcu7t5v0__aoi221_1 abstract view
.subckt gf180mcu_fd_sc_mcu7t5v0__aoi221_1 A1 A2 B1 B2 C ZN VDD VNW VPW VSS
.ends

* Black-box entry subcircuit for gf180mcu_fd_sc_mcu7t5v0__clkbuf_1 abstract view
.subckt gf180mcu_fd_sc_mcu7t5v0__clkbuf_1 I Z VDD VNW VPW VSS
.ends

* Black-box entry subcircuit for gf180mcu_fd_sc_mcu7t5v0__nor4_1 abstract view
.subckt gf180mcu_fd_sc_mcu7t5v0__nor4_1 A1 A2 A3 A4 ZN VDD VNW VPW VSS
.ends

* Black-box entry subcircuit for gf180mcu_fd_sc_mcu7t5v0__oai211_1 abstract view
.subckt gf180mcu_fd_sc_mcu7t5v0__oai211_1 A1 A2 B C ZN VDD VNW VPW VSS
.ends

* Black-box entry subcircuit for gf180mcu_fd_sc_mcu7t5v0__xnor2_1 abstract view
.subckt gf180mcu_fd_sc_mcu7t5v0__xnor2_1 A1 A2 ZN VDD VNW VPW VSS
.ends

* Black-box entry subcircuit for gf180mcu_fd_sc_mcu7t5v0__aoi222_1 abstract view
.subckt gf180mcu_fd_sc_mcu7t5v0__aoi222_1 A1 A2 B1 B2 C1 C2 ZN VDD VNW VPW VSS
.ends

* Black-box entry subcircuit for gf180mcu_fd_sc_mcu7t5v0__tieh abstract view
.subckt gf180mcu_fd_sc_mcu7t5v0__tieh Z VDD VNW VPW VSS
.ends

* Black-box entry subcircuit for gf180mcu_fd_sc_mcu7t5v0__xnor3_1 abstract view
.subckt gf180mcu_fd_sc_mcu7t5v0__xnor3_1 A1 A2 A3 ZN VDD VNW VPW VSS
.ends

.subckt trc_top VDD VSS iCLK iRST iSPI_CS iSPI_MOSI iSPI_SCK oINTERRUPT_CS oINTERRUPT_IE
+ oINTERRUPT_IN oINTERRUPT_OE oINTERRUPT_OUT oINTERRUPT_PD oINTERRUPT_PU oINTERRUPT_SL
+ oSPI_MISO_CS oSPI_MISO_IE oSPI_MISO_IN oSPI_MISO_OE oSPI_MISO_OUT oSPI_MISO_PD oSPI_MISO_PU
+ oSPI_MISO_SL
XFILLER_54_247 VDD VDD VSS VSS gf180mcu_fd_sc_mcu7t5v0__fillcap_64
XFILLER_10_317 VDD VDD VSS VSS gf180mcu_fd_sc_mcu7t5v0__fillcap_8
XTAP_TAPCELL_ROW_60_492 VDD VSS gf180mcu_fd_sc_mcu7t5v0__filltie
XFILLER_13_111 VDD VDD VSS VSS gf180mcu_fd_sc_mcu7t5v0__fill_1
XFILLER_26_85 VDD VDD VSS VSS gf180mcu_fd_sc_mcu7t5v0__fillcap_8
XFILLER_60_206 VDD VDD VSS VSS gf180mcu_fd_sc_mcu7t5v0__fillcap_32
X_501_ _675_/Q _671_/Q _702_/D _675_/D VDD VDD VSS VSS gf180mcu_fd_sc_mcu7t5v0__mux2_2
X_432_ _432_/A1 _432_/A2 _423_/B _432_/B _699_/D VDD VDD VSS VSS gf180mcu_fd_sc_mcu7t5v0__oai31_1
XFILLER_13_144 VDD VDD VSS VSS gf180mcu_fd_sc_mcu7t5v0__fill_1
X_363_ _675_/Q _671_/Q _365_/B VDD VDD VSS VSS gf180mcu_fd_sc_mcu7t5v0__and2_1
XFILLER_3_34 VDD VDD VSS VSS gf180mcu_fd_sc_mcu7t5v0__fillcap_4
XTAP_TAPCELL_ROW_8_181 VDD VSS gf180mcu_fd_sc_mcu7t5v0__filltie
XFILLER_36_247 VDD VDD VSS VSS gf180mcu_fd_sc_mcu7t5v0__fillcap_16
XFILLER_51_206 VDD VDD VSS VSS gf180mcu_fd_sc_mcu7t5v0__fillcap_4
XFILLER_35_291 VDD VDD VSS VSS gf180mcu_fd_sc_mcu7t5v0__fill_2
XFILLER_6_107 VDD VDD VSS VSS gf180mcu_fd_sc_mcu7t5v0__fillcap_4
XFILLER_2_313 VDD VDD VSS VSS gf180mcu_fd_sc_mcu7t5v0__fill_2
Xu_core.delay_paths.u_trc2.gen_inv_stage\[40\].inv u_core.delay_paths.u_trc2.gen_inv_stage\[40\].inv/I
+ u_core.delay_paths.u_trc2.gen_inv_stage\[41\].inv/I VDD VDD VSS VSS gf180mcu_fd_sc_mcu7t5v0__inv_1
XTAP_TAPCELL_ROW_5_162 VDD VSS gf180mcu_fd_sc_mcu7t5v0__filltie
XFILLER_53_72 VDD VDD VSS VSS gf180mcu_fd_sc_mcu7t5v0__fillcap_64
Xu_core.delay_paths.u_trc2.gen_inv_stage\[55\].inv u_core.delay_paths.u_trc2.gen_inv_stage\[55\].inv/I
+ u_core.delay_paths.u_trc2.gen_inv_stage\[56\].inv/I VDD VDD VSS VSS gf180mcu_fd_sc_mcu7t5v0__inv_1
X_415_ _415_/A1 _397_/B _415_/B1 _401_/Z _421_/A2 VDD VDD VSS VSS gf180mcu_fd_sc_mcu7t5v0__aoi22_1
X_346_ _346_/A1 _346_/A2 _346_/B _347_/B VDD VDD VSS VSS gf180mcu_fd_sc_mcu7t5v0__aoi21_1
XTAP_TAPCELL_ROW_28_297 VDD VSS gf180mcu_fd_sc_mcu7t5v0__filltie
XTAP_TAPCELL_ROW_11_197 VDD VSS gf180mcu_fd_sc_mcu7t5v0__filltie
XTAP_TAPCELL_ROW_19_242 VDD VSS gf180mcu_fd_sc_mcu7t5v0__filltie
XFILLER_20_401 VDD VDD VSS VSS gf180mcu_fd_sc_mcu7t5v0__fill_2
XFILLER_59_136 VDD VDD VSS VSS gf180mcu_fd_sc_mcu7t5v0__fillcap_4
XTAP_TAPCELL_ROW_2_143 VDD VSS gf180mcu_fd_sc_mcu7t5v0__filltie
Xu_core.delay_paths.u_trc1.gen_inv_stage\[142\].inv u_core.delay_paths.u_trc1.gen_inv_stage\[142\].inv/I
+ u_core.delay_paths.u_trc1.gen_inv_stage\[143\].inv/I VDD VDD VSS VSS gf180mcu_fd_sc_mcu7t5v0__inv_1
XTAP_TAPCELL_ROW_25_278 VDD VSS gf180mcu_fd_sc_mcu7t5v0__filltie
XFILLER_2_165 VDD VDD VSS VSS gf180mcu_fd_sc_mcu7t5v0__fill_2
XFILLER_48_61 VDD VDD VSS VSS gf180mcu_fd_sc_mcu7t5v0__fill_1
XFILLER_0_57 VDD VDD VSS VSS gf180mcu_fd_sc_mcu7t5v0__fill_1
XFILLER_21_209 VDD VDD VSS VSS gf180mcu_fd_sc_mcu7t5v0__fill_1
X_329_ _602_/I _611_/RN VDD VDD VSS VSS gf180mcu_fd_sc_mcu7t5v0__clkinv_1
XFILLER_9_66 VDD VDD VSS VSS gf180mcu_fd_sc_mcu7t5v0__fillcap_4
XFILLER_43_2 VDD VDD VSS VSS gf180mcu_fd_sc_mcu7t5v0__fillcap_64
Xu_core.delay_paths.u_trc1.gen_inv_stage\[94\].inv u_core.delay_paths.u_trc1.gen_inv_stage\[94\].inv/I
+ u_core.delay_paths.u_trc1.gen_inv_stage\[95\].inv/I VDD VDD VSS VSS gf180mcu_fd_sc_mcu7t5v0__inv_1
XPHY_EDGE_ROW_8_Left_69 VDD VSS gf180mcu_fd_sc_mcu7t5v0__endcap
X_680_ _680_/D _685_/RN _685_/CLK _680_/Q VDD VDD VSS VSS gf180mcu_fd_sc_mcu7t5v0__dffrnq_1
XFILLER_43_345 VDD VDD VSS VSS gf180mcu_fd_sc_mcu7t5v0__fillcap_4
Xu_core.delay_paths.u_trc1.gen_inv_stage\[32\].inv u_core.delay_paths.u_trc1.gen_inv_stage\[32\].inv/I
+ u_core.delay_paths.u_trc1.gen_inv_stage\[33\].inv/I VDD VDD VSS VSS gf180mcu_fd_sc_mcu7t5v0__inv_1
Xu_core.delay_paths.u_trc1.gen_inv_stage\[47\].inv u_core.delay_paths.u_trc1.gen_inv_stage\[47\].inv/I
+ u_core.delay_paths.u_trc1.gen_inv_stage\[48\].inv/I VDD VDD VSS VSS gf180mcu_fd_sc_mcu7t5v0__inv_1
Xload_slew30 _675_/RN _677_/RN VDD VDD VSS VSS gf180mcu_fd_sc_mcu7t5v0__buf_3
XTAP_TAPCELL_ROW_44_395 VDD VSS gf180mcu_fd_sc_mcu7t5v0__filltie
XFILLER_40_337 VDD VDD VSS VSS gf180mcu_fd_sc_mcu7t5v0__fillcap_32
XTAP_TAPCELL_ROW_35_340 VDD VSS gf180mcu_fd_sc_mcu7t5v0__filltie
Xhold63 _609_/Q _315_/I VDD VDD VSS VSS gf180mcu_fd_sc_mcu7t5v0__dlyc_1
XFILLER_16_301 VDD VDD VSS VSS gf180mcu_fd_sc_mcu7t5v0__fill_1
XFILLER_28_172 VDD VDD VSS VSS gf180mcu_fd_sc_mcu7t5v0__fill_2
XFILLER_45_84 VDD VDD VSS VSS gf180mcu_fd_sc_mcu7t5v0__fillcap_4
Xu_core.delay_paths.u_trc0.gen_inv_stage\[182\].inv u_core.delay_paths.u_trc0.gen_inv_stage\[182\].inv/I
+ u_core.delay_paths.u_trc0.gen_inv_stage\[183\].inv/I VDD VDD VSS VSS gf180mcu_fd_sc_mcu7t5v0__inv_1
X_663_ _663_/D wire28/Z _669_/CLK _663_/Q VDD VDD VSS VSS gf180mcu_fd_sc_mcu7t5v0__dffrnq_1
X_594_ _601_/I _625_/RN VDD VDD VSS VSS gf180mcu_fd_sc_mcu7t5v0__clkinv_1
XTAP_TAPCELL_ROW_58_476 VDD VSS gf180mcu_fd_sc_mcu7t5v0__filltie
XFILLER_6_34 VDD VDD VSS VSS gf180mcu_fd_sc_mcu7t5v0__fill_1
XTAP_TAPCELL_ROW_41_376 VDD VSS gf180mcu_fd_sc_mcu7t5v0__filltie
XFILLER_3_282 VDD VDD VSS VSS gf180mcu_fd_sc_mcu7t5v0__fill_1
XFILLER_6_78 VDD VDD VSS VSS gf180mcu_fd_sc_mcu7t5v0__fillcap_16
Xu_core.delay_paths.u_trc0.gen_inv_stage\[120\].inv u_core.delay_paths.u_trc0.gen_inv_stage\[120\].inv/I
+ u_core.delay_paths.u_trc0.gen_inv_stage\[121\].inv/I VDD VDD VSS VSS gf180mcu_fd_sc_mcu7t5v0__inv_1
XFILLER_19_150 VDD VDD VSS VSS gf180mcu_fd_sc_mcu7t5v0__fillcap_4
XFILLER_54_429 VDD VDD VSS VSS gf180mcu_fd_sc_mcu7t5v0__fill_1
Xu_core.delay_paths.u_trc0.gen_inv_stage\[135\].inv u_core.delay_paths.u_trc0.gen_inv_stage\[135\].inv/I
+ u_core.delay_paths.u_trc0.gen_inv_stage\[136\].inv/I VDD VDD VSS VSS gf180mcu_fd_sc_mcu7t5v0__inv_1
XTAP_TAPCELL_ROW_32_321 VDD VSS gf180mcu_fd_sc_mcu7t5v0__filltie
XFILLER_57_212 VDD VDD VSS VSS gf180mcu_fd_sc_mcu7t5v0__fillcap_64
Xu_core.delay_paths.u_trc0.gen_inv_stage\[71\].inv u_core.delay_paths.u_trc0.gen_inv_stage\[71\].inv/I
+ u_core.delay_paths.u_trc0.gen_inv_stage\[72\].inv/I VDD VDD VSS VSS gf180mcu_fd_sc_mcu7t5v0__clkinv_1
XFILLER_25_142 VDD VDD VSS VSS gf180mcu_fd_sc_mcu7t5v0__fillcap_16
Xu_core.delay_paths.u_trc0.gen_inv_stage\[86\].inv u_core.delay_paths.u_trc0.gen_inv_stage\[86\].inv/I
+ u_core.delay_paths.u_trc0.gen_inv_stage\[87\].inv/I VDD VDD VSS VSS gf180mcu_fd_sc_mcu7t5v0__inv_2
XFILLER_21_370 VDD VDD VSS VSS gf180mcu_fd_sc_mcu7t5v0__fillcap_4
Xu_core.delay_paths.u_trc0.gen_inv_stage\[24\].inv u_core.delay_paths.u_trc0.gen_inv_stage\[24\].inv/I
+ u_core.delay_paths.u_trc0.gen_inv_stage\[25\].inv/I VDD VDD VSS VSS gf180mcu_fd_sc_mcu7t5v0__inv_1
Xtrc_top_49 oSPI_MISO_CS VDD VDD VSS VSS gf180mcu_fd_sc_mcu7t5v0__tiel
XFILLER_0_274 VDD VDD VSS VSS gf180mcu_fd_sc_mcu7t5v0__fill_2
XFILLER_36_429 VDD VDD VSS VSS gf180mcu_fd_sc_mcu7t5v0__fill_1
Xu_core.delay_paths.u_trc0.gen_inv_stage\[39\].inv u_core.delay_paths.u_trc0.gen_inv_stage\[39\].inv/I
+ u_core.delay_paths.u_trc0.gen_inv_stage\[40\].inv/I VDD VDD VSS VSS gf180mcu_fd_sc_mcu7t5v0__inv_1
X_646_ _646_/D _687_/RN _688_/CLK _646_/Q VDD VDD VSS VSS gf180mcu_fd_sc_mcu7t5v0__dffsnq_1
X_577_ _577_/A1 _571_/Z _575_/Z _578_/A2 VDD VDD VSS VSS gf180mcu_fd_sc_mcu7t5v0__nor3_1
XFILLER_8_374 VDD VDD VSS VSS gf180mcu_fd_sc_mcu7t5v0__fillcap_4
XFILLER_39_212 VDD VDD VSS VSS gf180mcu_fd_sc_mcu7t5v0__fillcap_16
XFILLER_22_145 VDD VDD VSS VSS gf180mcu_fd_sc_mcu7t5v0__fillcap_8
XFILLER_22_189 VDD VDD VSS VSS gf180mcu_fd_sc_mcu7t5v0__fillcap_16
XTAP_TAPCELL_ROW_60_493 VDD VSS gf180mcu_fd_sc_mcu7t5v0__filltie
X_500_ _500_/A1 _504_/S _500_/B _674_/D VDD VDD VSS VSS gf180mcu_fd_sc_mcu7t5v0__aoi21_1
X_431_ _701_/Q _697_/Q _432_/B VDD VDD VSS VSS gf180mcu_fd_sc_mcu7t5v0__nor2_1
X_362_ _626_/D _362_/A2 _625_/D VDD VDD VSS VSS gf180mcu_fd_sc_mcu7t5v0__nor2_1
XPHY_EDGE_ROW_37_Left_98 VDD VSS gf180mcu_fd_sc_mcu7t5v0__endcap
XFILLER_9_105 VDD VDD VSS VSS gf180mcu_fd_sc_mcu7t5v0__fillcap_16
XPHY_EDGE_ROW_39_Left_100 VDD VSS gf180mcu_fd_sc_mcu7t5v0__endcap
Xu_core.delay_paths.u_trc0.gen_inv_stage\[1\].inv u_core.delay_paths.u_trc0.gen_inv_stage\[1\].inv/I
+ u_core.delay_paths.u_trc0.gen_inv_stage\[2\].inv/I VDD VDD VSS VSS gf180mcu_fd_sc_mcu7t5v0__inv_2
X_629_ _629_/D _629_/RN _626_/CLK _629_/Q VDD VDD VSS VSS gf180mcu_fd_sc_mcu7t5v0__dffnrnq_1
XFILLER_44_292 VDD VDD VSS VSS gf180mcu_fd_sc_mcu7t5v0__fillcap_16
XFILLER_8_193 VDD VDD VSS VSS gf180mcu_fd_sc_mcu7t5v0__fill_1
Xu_core.delay_paths.u_trc2.gen_inv_stage\[0\].inv _722_/I u_core.delay_paths.u_trc2.gen_inv_stage\[1\].inv/I
+ VDD VDD VSS VSS gf180mcu_fd_sc_mcu7t5v0__inv_1
XFILLER_42_207 VDD VDD VSS VSS gf180mcu_fd_sc_mcu7t5v0__fillcap_16
XFILLER_12_77 VDD VDD VSS VSS gf180mcu_fd_sc_mcu7t5v0__fill_2
XFILLER_12_99 VDD VDD VSS VSS gf180mcu_fd_sc_mcu7t5v0__fillcap_4
XFILLER_2_303 VDD VDD VSS VSS gf180mcu_fd_sc_mcu7t5v0__fill_1
XFILLER_37_74 VDD VDD VSS VSS gf180mcu_fd_sc_mcu7t5v0__fill_1
Xu_core.delay_paths.u_trc3.gen_inv_stage\[15\].inv u_core.delay_paths.u_trc3.gen_inv_stage\[15\].inv/I
+ u_core.delay_paths.u_trc3.gen_inv_stage\[16\].inv/I VDD VDD VSS VSS gf180mcu_fd_sc_mcu7t5v0__inv_1
XTAP_TAPCELL_ROW_5_163 VDD VSS gf180mcu_fd_sc_mcu7t5v0__filltie
XFILLER_41_251 VDD VDD VSS VSS gf180mcu_fd_sc_mcu7t5v0__fillcap_16
X_414_ _639_/Q _428_/A2 _428_/B _414_/C _698_/D VDD VDD VSS VSS gf180mcu_fd_sc_mcu7t5v0__aoi211_1
X_345_ _652_/Q _522_/A1 _345_/B _346_/A2 VDD VDD VSS VSS gf180mcu_fd_sc_mcu7t5v0__oai21_1
XTAP_TAPCELL_ROW_28_298 VDD VSS gf180mcu_fd_sc_mcu7t5v0__filltie
XFILLER_5_174 VDD VDD VSS VSS gf180mcu_fd_sc_mcu7t5v0__fillcap_16
XTAP_TAPCELL_ROW_11_198 VDD VSS gf180mcu_fd_sc_mcu7t5v0__filltie
XFILLER_1_391 VDD VDD VSS VSS gf180mcu_fd_sc_mcu7t5v0__fillcap_16
XTAP_TAPCELL_ROW_19_243 VDD VSS gf180mcu_fd_sc_mcu7t5v0__filltie
XFILLER_32_251 VDD VDD VSS VSS gf180mcu_fd_sc_mcu7t5v0__fill_2
XPHY_EDGE_ROW_12_Right_12 VDD VSS gf180mcu_fd_sc_mcu7t5v0__endcap
XFILLER_15_207 VDD VDD VSS VSS gf180mcu_fd_sc_mcu7t5v0__fill_2
XTAP_TAPCELL_ROW_2_144 VDD VSS gf180mcu_fd_sc_mcu7t5v0__filltie
XPHY_EDGE_ROW_21_Right_21 VDD VSS gf180mcu_fd_sc_mcu7t5v0__endcap
XTAP_TAPCELL_ROW_25_279 VDD VSS gf180mcu_fd_sc_mcu7t5v0__filltie
XFILLER_23_76 VDD VDD VSS VSS gf180mcu_fd_sc_mcu7t5v0__fill_2
XPHY_EDGE_ROW_30_Right_30 VDD VSS gf180mcu_fd_sc_mcu7t5v0__endcap
XFILLER_2_177 VDD VDD VSS VSS gf180mcu_fd_sc_mcu7t5v0__fill_2
XFILLER_3_2 VDD VDD VSS VSS gf180mcu_fd_sc_mcu7t5v0__fillcap_32
XFILLER_0_36 VDD VDD VSS VSS gf180mcu_fd_sc_mcu7t5v0__fillcap_16
XFILLER_46_387 VDD VDD VSS VSS gf180mcu_fd_sc_mcu7t5v0__fillcap_32
XTAP_TAPCELL_ROW_16_224 VDD VSS gf180mcu_fd_sc_mcu7t5v0__filltie
XFILLER_14_273 VDD VDD VSS VSS gf180mcu_fd_sc_mcu7t5v0__fill_1
X_328_ _632_/Q _456_/A1 VDD VDD VSS VSS gf180mcu_fd_sc_mcu7t5v0__clkinv_1
XFILLER_36_2 VDD VDD VSS VSS gf180mcu_fd_sc_mcu7t5v0__fillcap_32
XPHY_EDGE_ROW_24_Left_85 VDD VSS gf180mcu_fd_sc_mcu7t5v0__endcap
XFILLER_37_343 VDD VDD VSS VSS gf180mcu_fd_sc_mcu7t5v0__fillcap_4
XFILLER_56_107 VDD VDD VSS VSS gf180mcu_fd_sc_mcu7t5v0__fillcap_64
Xu_core.delay_paths.u_trc2.gen_inv_stage\[54\].inv u_core.delay_paths.u_trc2.gen_inv_stage\[54\].inv/I
+ u_core.delay_paths.u_trc2.gen_inv_stage\[55\].inv/I VDD VDD VSS VSS gf180mcu_fd_sc_mcu7t5v0__inv_1
XFILLER_28_387 VDD VDD VSS VSS gf180mcu_fd_sc_mcu7t5v0__fillcap_32
XFILLER_43_313 VDD VDD VSS VSS gf180mcu_fd_sc_mcu7t5v0__fillcap_32
XFILLER_47_129 VDD VDD VSS VSS gf180mcu_fd_sc_mcu7t5v0__fillcap_4
Xu_core.delay_paths.u_trc2.gen_inv_stage\[69\].inv u_core.delay_paths.u_trc2.gen_inv_stage\[69\].inv/I
+ u_core.delay_paths.u_trc2.gen_inv_stage\[70\].inv/I VDD VDD VSS VSS gf180mcu_fd_sc_mcu7t5v0__inv_1
XTAP_TAPCELL_ROW_38_360 VDD VSS gf180mcu_fd_sc_mcu7t5v0__filltie
XFILLER_11_243 VDD VDD VSS VSS gf180mcu_fd_sc_mcu7t5v0__fillcap_4
XFILLER_34_64 VDD VDD VSS VSS gf180mcu_fd_sc_mcu7t5v0__fillcap_16
XFILLER_19_354 VDD VDD VSS VSS gf180mcu_fd_sc_mcu7t5v0__fill_1
XFILLER_38_107 VDD VDD VSS VSS gf180mcu_fd_sc_mcu7t5v0__fillcap_8
XFILLER_59_72 VDD VDD VSS VSS gf180mcu_fd_sc_mcu7t5v0__fillcap_64
Xload_slew42 _705_/RN _661_/RN VDD VDD VSS VSS gf180mcu_fd_sc_mcu7t5v0__buf_4
XTAP_TAPCELL_ROW_44_396 VDD VSS gf180mcu_fd_sc_mcu7t5v0__filltie
Xu_core.delay_paths.u_trc1.gen_inv_stage\[141\].inv u_core.delay_paths.u_trc1.gen_inv_stage\[141\].inv/I
+ u_core.delay_paths.u_trc1.gen_inv_stage\[142\].inv/I VDD VDD VSS VSS gf180mcu_fd_sc_mcu7t5v0__inv_1
XFILLER_57_416 VDD VDD VSS VSS gf180mcu_fd_sc_mcu7t5v0__fillcap_4
XFILLER_37_162 VDD VDD VSS VSS gf180mcu_fd_sc_mcu7t5v0__fillcap_4
XTAP_TAPCELL_ROW_35_341 VDD VSS gf180mcu_fd_sc_mcu7t5v0__filltie
Xu_core.delay_paths.u_trc1.gen_inv_stage\[109\].inv u_core.delay_paths.u_trc1.gen_inv_stage\[109\].inv/I
+ u_core.delay_paths.u_trc1.gen_inv_stage\[110\].inv/I VDD VDD VSS VSS gf180mcu_fd_sc_mcu7t5v0__inv_1
XFILLER_28_140 VDD VDD VSS VSS gf180mcu_fd_sc_mcu7t5v0__fill_1
XFILLER_48_427 VDD VDD VSS VSS gf180mcu_fd_sc_mcu7t5v0__fill_2
Xhold64 hold64/I _704_/D VDD VDD VSS VSS gf180mcu_fd_sc_mcu7t5v0__dlyc_1
X_662_ _662_/D _675_/RN _669_/CLK _662_/Q VDD VDD VSS VSS gf180mcu_fd_sc_mcu7t5v0__dffrnq_1
XFILLER_31_316 VDD VDD VSS VSS gf180mcu_fd_sc_mcu7t5v0__fillcap_4
X_593_ _601_/I _624_/RN VDD VDD VSS VSS gf180mcu_fd_sc_mcu7t5v0__clkinv_1
XTAP_TAPCELL_ROW_58_477 VDD VSS gf180mcu_fd_sc_mcu7t5v0__filltie
XTAP_TAPCELL_ROW_41_377 VDD VSS gf180mcu_fd_sc_mcu7t5v0__filltie
XFILLER_39_416 VDD VDD VSS VSS gf180mcu_fd_sc_mcu7t5v0__fillcap_4
XFILLER_3_294 VDD VDD VSS VSS gf180mcu_fd_sc_mcu7t5v0__fill_2
XFILLER_54_419 VDD VDD VSS VSS gf180mcu_fd_sc_mcu7t5v0__fillcap_8
XTAP_TAPCELL_ROW_49_422 VDD VSS gf180mcu_fd_sc_mcu7t5v0__filltie
XFILLER_30_360 VDD VDD VSS VSS gf180mcu_fd_sc_mcu7t5v0__fillcap_16
Xu_core.delay_paths.u_trc1.gen_inv_stage\[93\].inv u_core.delay_paths.u_trc1.gen_inv_stage\[93\].inv/I
+ u_core.delay_paths.u_trc1.gen_inv_stage\[94\].inv/I VDD VDD VSS VSS gf180mcu_fd_sc_mcu7t5v0__inv_1
XTAP_TAPCELL_ROW_32_322 VDD VSS gf180mcu_fd_sc_mcu7t5v0__filltie
XPHY_EDGE_ROW_6_Right_6 VDD VSS gf180mcu_fd_sc_mcu7t5v0__endcap
Xu_core.delay_paths.u_trc1.gen_inv_stage\[31\].inv u_core.delay_paths.u_trc1.gen_inv_stage\[31\].inv/I
+ u_core.delay_paths.u_trc1.gen_inv_stage\[32\].inv/I VDD VDD VSS VSS gf180mcu_fd_sc_mcu7t5v0__inv_1
XFILLER_13_349 VDD VDD VSS VSS gf180mcu_fd_sc_mcu7t5v0__fill_1
XFILLER_15_66 VDD VDD VSS VSS gf180mcu_fd_sc_mcu7t5v0__fillcap_4
Xu_core.delay_paths.u_trc1.gen_inv_stage\[46\].inv u_core.delay_paths.u_trc1.gen_inv_stage\[46\].inv/I
+ u_core.delay_paths.u_trc1.gen_inv_stage\[47\].inv/I VDD VDD VSS VSS gf180mcu_fd_sc_mcu7t5v0__inv_1
XTAP_TAPCELL_ROW_55_458 VDD VSS gf180mcu_fd_sc_mcu7t5v0__filltie
XPHY_EDGE_ROW_11_Left_72 VDD VSS gf180mcu_fd_sc_mcu7t5v0__endcap
XFILLER_15_88 VDD VDD VSS VSS gf180mcu_fd_sc_mcu7t5v0__fillcap_8
XFILLER_0_297 VDD VDD VSS VSS gf180mcu_fd_sc_mcu7t5v0__fill_2
XFILLER_36_419 VDD VDD VSS VSS gf180mcu_fd_sc_mcu7t5v0__fillcap_8
X_645_ _645_/D _704_/RN _704_/CLK _645_/Q VDD VDD VSS VSS gf180mcu_fd_sc_mcu7t5v0__dffsnq_1
XFILLER_16_187 VDD VDD VSS VSS gf180mcu_fd_sc_mcu7t5v0__fill_1
X_576_ _571_/Z _575_/Z _579_/B1 VDD VDD VSS VSS gf180mcu_fd_sc_mcu7t5v0__nand2_1
XPHY_EDGE_ROW_59_Right_59 VDD VSS gf180mcu_fd_sc_mcu7t5v0__endcap
XFILLER_8_353 VDD VDD VSS VSS gf180mcu_fd_sc_mcu7t5v0__fillcap_8
XFILLER_27_408 VDD VDD VSS VSS gf180mcu_fd_sc_mcu7t5v0__fillcap_8
XFILLER_39_235 VDD VDD VSS VSS gf180mcu_fd_sc_mcu7t5v0__fillcap_4
XFILLER_22_124 VDD VDD VSS VSS gf180mcu_fd_sc_mcu7t5v0__fill_1
XTAP_TAPCELL_ROW_60_494 VDD VSS gf180mcu_fd_sc_mcu7t5v0__filltie
Xu_core.delay_paths.u_trc0.gen_inv_stage\[181\].inv u_core.delay_paths.u_trc0.gen_inv_stage\[181\].inv/I
+ u_core.delay_paths.u_trc0.gen_inv_stage\[182\].inv/I VDD VDD VSS VSS gf180mcu_fd_sc_mcu7t5v0__inv_1
XFILLER_41_422 VDD VDD VSS VSS gf180mcu_fd_sc_mcu7t5v0__fillcap_8
XFILLER_53_282 VDD VDD VSS VSS gf180mcu_fd_sc_mcu7t5v0__fillcap_64
X_430_ _430_/I _700_/D VDD VDD VSS VSS gf180mcu_fd_sc_mcu7t5v0__clkinv_1
X_361_ _624_/Q _623_/Q _625_/Q _362_/A2 VDD VDD VSS VSS gf180mcu_fd_sc_mcu7t5v0__aoi21_1
XFILLER_42_75 VDD VDD VSS VSS gf180mcu_fd_sc_mcu7t5v0__fill_2
Xu_core.delay_paths.u_trc0.gen_inv_stage\[134\].inv u_core.delay_paths.u_trc0.gen_inv_stage\[134\].inv/I
+ u_core.delay_paths.u_trc0.gen_inv_stage\[135\].inv/I VDD VDD VSS VSS gf180mcu_fd_sc_mcu7t5v0__inv_1
XFILLER_3_58 VDD VDD VSS VSS gf180mcu_fd_sc_mcu7t5v0__fillcap_8
Xu_core.delay_paths.u_trc0.gen_inv_stage\[149\].inv u_core.delay_paths.u_trc0.gen_inv_stage\[149\].inv/I
+ u_core.delay_paths.u_trc0.gen_inv_stage\[150\].inv/I VDD VDD VSS VSS gf180mcu_fd_sc_mcu7t5v0__inv_1
XFILLER_29_290 VDD VDD VSS VSS gf180mcu_fd_sc_mcu7t5v0__fill_2
X_628_ _628_/D _628_/RN _615_/CLK _628_/Q VDD VDD VSS VSS gf180mcu_fd_sc_mcu7t5v0__dffnrnq_1
Xu_core.delay_paths.u_trc0.gen_inv_stage\[70\].inv u_core.delay_paths.u_trc0.gen_inv_stage\[70\].inv/I
+ u_core.delay_paths.u_trc0.gen_inv_stage\[71\].inv/I VDD VDD VSS VSS gf180mcu_fd_sc_mcu7t5v0__clkinv_1
X_559_ _701_/Q _570_/B _582_/A1 VDD VDD VSS VSS gf180mcu_fd_sc_mcu7t5v0__nand2_1
Xu_core.delay_paths.u_trc0.gen_inv_stage\[85\].inv u_core.delay_paths.u_trc0.gen_inv_stage\[85\].inv/I
+ u_core.delay_paths.u_trc0.gen_inv_stage\[86\].inv/I VDD VDD VSS VSS gf180mcu_fd_sc_mcu7t5v0__inv_2
XFILLER_23_411 VDD VDD VSS VSS gf180mcu_fd_sc_mcu7t5v0__fill_1
XFILLER_23_422 VDD VDD VSS VSS gf180mcu_fd_sc_mcu7t5v0__fill_2
XFILLER_35_282 VDD VDD VSS VSS gf180mcu_fd_sc_mcu7t5v0__fill_1
XFILLER_35_293 VDD VDD VSS VSS gf180mcu_fd_sc_mcu7t5v0__fill_1
XFILLER_50_241 VDD VDD VSS VSS gf180mcu_fd_sc_mcu7t5v0__fillcap_4
Xu_core.delay_paths.u_trc0.gen_inv_stage\[23\].inv u_core.delay_paths.u_trc0.gen_inv_stage\[23\].inv/I
+ u_core.delay_paths.u_trc0.gen_inv_stage\[24\].inv/I VDD VDD VSS VSS gf180mcu_fd_sc_mcu7t5v0__inv_1
Xu_core.delay_paths.u_trc0.gen_inv_stage\[38\].inv u_core.delay_paths.u_trc0.gen_inv_stage\[38\].inv/I
+ u_core.delay_paths.u_trc0.gen_inv_stage\[39\].inv/I VDD VDD VSS VSS gf180mcu_fd_sc_mcu7t5v0__inv_1
XFILLER_12_34 VDD VDD VSS VSS gf180mcu_fd_sc_mcu7t5v0__fill_1
X_413_ _639_/Q _413_/A2 _413_/B _428_/B VDD VDD VSS VSS gf180mcu_fd_sc_mcu7t5v0__oai21_1
XTAP_TAPCELL_ROW_28_299 VDD VSS gf180mcu_fd_sc_mcu7t5v0__filltie
X_344_ _338_/B _344_/A2 _346_/A1 _344_/Z VDD VDD VSS VSS gf180mcu_fd_sc_mcu7t5v0__and3_1
XFILLER_5_142 VDD VDD VSS VSS gf180mcu_fd_sc_mcu7t5v0__fillcap_32
XTAP_TAPCELL_ROW_11_199 VDD VSS gf180mcu_fd_sc_mcu7t5v0__filltie
XFILLER_49_352 VDD VDD VSS VSS gf180mcu_fd_sc_mcu7t5v0__fillcap_64
XFILLER_17_282 VDD VDD VSS VSS gf180mcu_fd_sc_mcu7t5v0__fillcap_16
XTAP_TAPCELL_ROW_19_244 VDD VSS gf180mcu_fd_sc_mcu7t5v0__filltie
XPHY_EDGE_ROW_58_Left_119 VDD VSS gf180mcu_fd_sc_mcu7t5v0__endcap
XTAP_TAPCELL_ROW_2_145 VDD VSS gf180mcu_fd_sc_mcu7t5v0__filltie
XFILLER_23_66 VDD VDD VSS VSS gf180mcu_fd_sc_mcu7t5v0__fillcap_4
Xu_core.delay_paths.u_trc0.gen_inv_stage\[0\].inv _718_/I u_core.delay_paths.u_trc0.gen_inv_stage\[1\].inv/I
+ VDD VDD VSS VSS gf180mcu_fd_sc_mcu7t5v0__inv_2
XFILLER_2_167 VDD VDD VSS VSS gf180mcu_fd_sc_mcu7t5v0__fill_1
XFILLER_46_311 VDD VDD VSS VSS gf180mcu_fd_sc_mcu7t5v0__fillcap_4
XFILLER_58_171 VDD VDD VSS VSS gf180mcu_fd_sc_mcu7t5v0__fillcap_4
XFILLER_14_241 VDD VDD VSS VSS gf180mcu_fd_sc_mcu7t5v0__fillcap_4
XTAP_TAPCELL_ROW_16_225 VDD VSS gf180mcu_fd_sc_mcu7t5v0__filltie
X_327_ _631_/Q _454_/A1 VDD VDD VSS VSS gf180mcu_fd_sc_mcu7t5v0__clkinv_1
XFILLER_29_2 VDD VDD VSS VSS gf180mcu_fd_sc_mcu7t5v0__fillcap_32
XFILLER_20_233 VDD VDD VSS VSS gf180mcu_fd_sc_mcu7t5v0__fillcap_4
Xu_core.delay_paths.u_trc3.gen_inv_stage\[14\].inv u_core.delay_paths.u_trc3.gen_inv_stage\[14\].inv/I
+ u_core.delay_paths.u_trc3.gen_inv_stage\[15\].inv/I VDD VDD VSS VSS gf180mcu_fd_sc_mcu7t5v0__inv_1
Xu_core.delay_paths.u_trc3.gen_inv_stage\[29\].inv u_core.delay_paths.u_trc3.gen_inv_stage\[29\].inv/I
+ u_core.delay_paths.u_trc3.gen_inv_stage\[30\].inv/I VDD VDD VSS VSS gf180mcu_fd_sc_mcu7t5v0__inv_1
XTAP_TAPCELL_ROW_38_361 VDD VSS gf180mcu_fd_sc_mcu7t5v0__filltie
XTAP_TAPCELL_ROW_13_206 VDD VSS gf180mcu_fd_sc_mcu7t5v0__filltie
XFILLER_11_222 VDD VDD VSS VSS gf180mcu_fd_sc_mcu7t5v0__fill_2
XFILLER_11_277 VDD VDD VSS VSS gf180mcu_fd_sc_mcu7t5v0__fill_2
XFILLER_19_344 VDD VDD VSS VSS gf180mcu_fd_sc_mcu7t5v0__fillcap_4
XFILLER_34_325 VDD VDD VSS VSS gf180mcu_fd_sc_mcu7t5v0__fillcap_16
XFILLER_46_152 VDD VDD VSS VSS gf180mcu_fd_sc_mcu7t5v0__fill_2
XTAP_TAPCELL_ROW_44_397 VDD VSS gf180mcu_fd_sc_mcu7t5v0__filltie
XFILLER_40_317 VDD VDD VSS VSS gf180mcu_fd_sc_mcu7t5v0__fillcap_4
XFILLER_52_177 VDD VDD VSS VSS gf180mcu_fd_sc_mcu7t5v0__fillcap_64
XTAP_TAPCELL_ROW_35_342 VDD VSS gf180mcu_fd_sc_mcu7t5v0__filltie
XFILLER_20_34 VDD VDD VSS VSS gf180mcu_fd_sc_mcu7t5v0__fill_1
XFILLER_28_174 VDD VDD VSS VSS gf180mcu_fd_sc_mcu7t5v0__fill_1
XFILLER_43_100 VDD VDD VSS VSS gf180mcu_fd_sc_mcu7t5v0__fill_1
Xhold65 _702_/Q _310_/I VDD VDD VSS VSS gf180mcu_fd_sc_mcu7t5v0__dlyc_1
X_661_ _661_/D _661_/RN _703_/CLK _661_/Q VDD VDD VSS VSS gf180mcu_fd_sc_mcu7t5v0__dffrnq_1
X_592_ _601_/I _623_/RN VDD VDD VSS VSS gf180mcu_fd_sc_mcu7t5v0__clkinv_1
XTAP_TAPCELL_ROW_58_478 VDD VSS gf180mcu_fd_sc_mcu7t5v0__filltie
XFILLER_24_391 VDD VDD VSS VSS gf180mcu_fd_sc_mcu7t5v0__fill_1
XTAP_TAPCELL_ROW_41_378 VDD VSS gf180mcu_fd_sc_mcu7t5v0__filltie
XTAP_TAPCELL_ROW_49_423 VDD VSS gf180mcu_fd_sc_mcu7t5v0__filltie
XFILLER_19_130 VDD VDD VSS VSS gf180mcu_fd_sc_mcu7t5v0__fillcap_8
XFILLER_19_196 VDD VDD VSS VSS gf180mcu_fd_sc_mcu7t5v0__fillcap_8
Xu_core.delay_paths.u_trc2.gen_inv_stage\[53\].inv u_core.delay_paths.u_trc2.gen_inv_stage\[53\].inv/I
+ u_core.delay_paths.u_trc2.gen_inv_stage\[54\].inv/I VDD VDD VSS VSS gf180mcu_fd_sc_mcu7t5v0__inv_1
Xu_core.delay_paths.u_trc2.gen_inv_stage\[68\].inv u_core.delay_paths.u_trc2.gen_inv_stage\[68\].inv/I
+ u_core.delay_paths.u_trc2.gen_inv_stage\[69\].inv/I VDD VDD VSS VSS gf180mcu_fd_sc_mcu7t5v0__inv_1
XTAP_TAPCELL_ROW_32_323 VDD VSS gf180mcu_fd_sc_mcu7t5v0__filltie
XFILLER_40_103 VDD VDD VSS VSS gf180mcu_fd_sc_mcu7t5v0__fill_2
XFILLER_40_125 VDD VDD VSS VSS gf180mcu_fd_sc_mcu7t5v0__fill_2
XTAP_TAPCELL_ROW_55_459 VDD VSS gf180mcu_fd_sc_mcu7t5v0__filltie
XFILLER_31_66 VDD VDD VSS VSS gf180mcu_fd_sc_mcu7t5v0__fillcap_4
XFILLER_40_169 VDD VDD VSS VSS gf180mcu_fd_sc_mcu7t5v0__fillcap_4
XFILLER_0_276 VDD VDD VSS VSS gf180mcu_fd_sc_mcu7t5v0__fill_1
XFILLER_16_155 VDD VDD VSS VSS gf180mcu_fd_sc_mcu7t5v0__fillcap_4
XFILLER_48_247 VDD VDD VSS VSS gf180mcu_fd_sc_mcu7t5v0__fillcap_64
Xu_core.delay_paths.u_trc1.gen_inv_stage\[140\].inv u_core.delay_paths.u_trc1.gen_inv_stage\[140\].inv/I
+ u_core.delay_paths.u_trc1.gen_inv_stage\[141\].inv/I VDD VDD VSS VSS gf180mcu_fd_sc_mcu7t5v0__inv_1
X_644_ _644_/D _687_/RN _644_/CLK _644_/Q VDD VDD VSS VSS gf180mcu_fd_sc_mcu7t5v0__dffrnq_1
X_575_ _660_/Q _556_/Z _575_/Z VDD VDD VSS VSS gf180mcu_fd_sc_mcu7t5v0__xor2_1
XTAP_TAPCELL_ROW_46_404 VDD VSS gf180mcu_fd_sc_mcu7t5v0__filltie
XFILLER_12_383 VDD VDD VSS VSS gf180mcu_fd_sc_mcu7t5v0__fill_2
XFILLER_16_177 VDD VDD VSS VSS gf180mcu_fd_sc_mcu7t5v0__fillcap_8
XFILLER_8_310 VDD VDD VSS VSS gf180mcu_fd_sc_mcu7t5v0__fillcap_4
XFILLER_11_2 VDD VDD VSS VSS gf180mcu_fd_sc_mcu7t5v0__fillcap_64
XFILLER_39_203 VDD VDD VSS VSS gf180mcu_fd_sc_mcu7t5v0__fillcap_4
Xu_core.delay_paths.u_trc1.gen_inv_stage\[108\].inv u_core.delay_paths.u_trc1.gen_inv_stage\[108\].inv/I
+ u_core.delay_paths.u_trc1.gen_inv_stage\[109\].inv/I VDD VDD VSS VSS gf180mcu_fd_sc_mcu7t5v0__inv_1
XTAP_TAPCELL_ROW_60_495 VDD VSS gf180mcu_fd_sc_mcu7t5v0__filltie
XFILLER_13_169 VDD VDD VSS VSS gf180mcu_fd_sc_mcu7t5v0__fill_1
XFILLER_26_77 VDD VDD VSS VSS gf180mcu_fd_sc_mcu7t5v0__fillcap_4
XFILLER_42_87 VDD VDD VSS VSS gf180mcu_fd_sc_mcu7t5v0__fill_2
X_360_ _624_/Q _623_/Q _625_/Q _626_/D VDD VDD VSS VSS gf180mcu_fd_sc_mcu7t5v0__and3_1
Xu_core.delay_paths.u_trc1.gen_inv_stage\[92\].inv u_core.delay_paths.u_trc1.gen_inv_stage\[92\].inv/I
+ u_core.delay_paths.u_trc1.gen_inv_stage\[93\].inv/I VDD VDD VSS VSS gf180mcu_fd_sc_mcu7t5v0__inv_1
XFILLER_36_228 VDD VDD VSS VSS gf180mcu_fd_sc_mcu7t5v0__fillcap_4
X_627_ _627_/D _627_/RN _615_/CLK _627_/Q VDD VDD VSS VSS gf180mcu_fd_sc_mcu7t5v0__dffnrnq_1
X_558_ _570_/B _562_/B1 VDD VDD VSS VSS gf180mcu_fd_sc_mcu7t5v0__clkinv_1
Xu_core.delay_paths.u_trc1.gen_inv_stage\[30\].inv u_core.delay_paths.u_trc1.gen_inv_stage\[30\].inv/I
+ u_core.delay_paths.u_trc1.gen_inv_stage\[31\].inv/I VDD VDD VSS VSS gf180mcu_fd_sc_mcu7t5v0__inv_1
Xu_core.delay_paths.u_trc1.gen_inv_stage\[45\].inv u_core.delay_paths.u_trc1.gen_inv_stage\[45\].inv/I
+ u_core.delay_paths.u_trc1.gen_inv_stage\[46\].inv/I VDD VDD VSS VSS gf180mcu_fd_sc_mcu7t5v0__inv_1
X_489_ _668_/Q _667_/Q _489_/A3 _491_/A2 VDD VDD VSS VSS gf180mcu_fd_sc_mcu7t5v0__nand3_1
XFILLER_59_2 VDD VDD VSS VSS gf180mcu_fd_sc_mcu7t5v0__fillcap_64
XFILLER_10_117 VDD VDD VSS VSS gf180mcu_fd_sc_mcu7t5v0__fillcap_16
XFILLER_41_220 VDD VDD VSS VSS gf180mcu_fd_sc_mcu7t5v0__fillcap_4
XFILLER_41_231 VDD VDD VSS VSS gf180mcu_fd_sc_mcu7t5v0__fillcap_4
X_412_ _663_/Q _664_/Q _665_/Q _413_/A2 VDD VDD VSS VSS gf180mcu_fd_sc_mcu7t5v0__nor3_1
X_343_ _343_/A1 _341_/Z _352_/B2 _343_/Z VDD VDD VSS VSS gf180mcu_fd_sc_mcu7t5v0__and3_1
XFILLER_5_198 VDD VDD VSS VSS gf180mcu_fd_sc_mcu7t5v0__fillcap_4
XTAP_TAPCELL_ROW_19_245 VDD VSS gf180mcu_fd_sc_mcu7t5v0__filltie
XFILLER_32_253 VDD VDD VSS VSS gf180mcu_fd_sc_mcu7t5v0__fill_1
Xu_core.delay_paths.u_trc0.gen_inv_stage\[180\].inv u_core.delay_paths.u_trc0.gen_inv_stage\[180\].inv/I
+ u_core.delay_paths.u_trc0.gen_inv_stage\[181\].inv/I VDD VDD VSS VSS gf180mcu_fd_sc_mcu7t5v0__inv_1
XFILLER_4_80 VDD VDD VSS VSS gf180mcu_fd_sc_mcu7t5v0__fill_1
XFILLER_15_209 VDD VDD VSS VSS gf180mcu_fd_sc_mcu7t5v0__fill_1
XFILLER_23_220 VDD VDD VSS VSS gf180mcu_fd_sc_mcu7t5v0__fillcap_4
Xu_core.delay_paths.u_trc0.gen_inv_stage\[133\].inv u_core.delay_paths.u_trc0.gen_inv_stage\[133\].inv/I
+ u_core.delay_paths.u_trc0.gen_inv_stage\[134\].inv/I VDD VDD VSS VSS gf180mcu_fd_sc_mcu7t5v0__inv_1
XFILLER_11_415 VDD VDD VSS VSS gf180mcu_fd_sc_mcu7t5v0__fillcap_4
XFILLER_23_264 VDD VDD VSS VSS gf180mcu_fd_sc_mcu7t5v0__fill_1
XFILLER_23_286 VDD VDD VSS VSS gf180mcu_fd_sc_mcu7t5v0__fill_2
XFILLER_23_78 VDD VDD VSS VSS gf180mcu_fd_sc_mcu7t5v0__fill_1
Xu_core.delay_paths.u_trc0.gen_inv_stage\[148\].inv u_core.delay_paths.u_trc0.gen_inv_stage\[148\].inv/I
+ u_core.delay_paths.u_trc0.gen_inv_stage\[149\].inv/I VDD VDD VSS VSS gf180mcu_fd_sc_mcu7t5v0__inv_1
XFILLER_48_53 VDD VDD VSS VSS gf180mcu_fd_sc_mcu7t5v0__fillcap_8
Xmax_cap8 _574_/A1 _584_/B2 VDD VDD VSS VSS gf180mcu_fd_sc_mcu7t5v0__buf_2
Xu_core.delay_paths.u_trc0.gen_inv_stage\[84\].inv u_core.delay_paths.u_trc0.gen_inv_stage\[84\].inv/I
+ u_core.delay_paths.u_trc0.gen_inv_stage\[85\].inv/I VDD VDD VSS VSS gf180mcu_fd_sc_mcu7t5v0__inv_2
X_326_ _630_/Q _451_/A1 VDD VDD VSS VSS gf180mcu_fd_sc_mcu7t5v0__clkinv_1
XTAP_TAPCELL_ROW_16_226 VDD VSS gf180mcu_fd_sc_mcu7t5v0__filltie
Xu_core.delay_paths.u_trc0.gen_inv_stage\[22\].inv u_core.delay_paths.u_trc0.gen_inv_stage\[22\].inv/I
+ u_core.delay_paths.u_trc0.gen_inv_stage\[23\].inv/I VDD VDD VSS VSS gf180mcu_fd_sc_mcu7t5v0__inv_1
Xu_core.delay_paths.u_trc0.gen_inv_stage\[99\].inv u_core.delay_paths.u_trc0.gen_inv_stage\[99\].inv/I
+ u_core.delay_paths.u_trc0.gen_inv_stage\[99\].inv/ZN VDD VDD VSS VSS gf180mcu_fd_sc_mcu7t5v0__inv_2
Xu_core.delay_paths.u_trc0.gen_inv_stage\[37\].inv u_core.delay_paths.u_trc0.gen_inv_stage\[37\].inv/I
+ u_core.delay_paths.u_trc0.gen_inv_stage\[38\].inv/I VDD VDD VSS VSS gf180mcu_fd_sc_mcu7t5v0__inv_1
XFILLER_37_312 VDD VDD VSS VSS gf180mcu_fd_sc_mcu7t5v0__fillcap_4
XFILLER_18_34 VDD VDD VSS VSS gf180mcu_fd_sc_mcu7t5v0__fill_1
XFILLER_28_301 VDD VDD VSS VSS gf180mcu_fd_sc_mcu7t5v0__fill_1
XFILLER_55_142 VDD VDD VSS VSS gf180mcu_fd_sc_mcu7t5v0__fillcap_64
Xclkbuf_4_15__f_iCLK clkbuf_0_iCLK/Z _693_/CLK VDD VDD VSS VSS gf180mcu_fd_sc_mcu7t5v0__clkbuf_16
XFILLER_11_212 VDD VDD VSS VSS gf180mcu_fd_sc_mcu7t5v0__fill_2
XFILLER_34_88 VDD VDD VSS VSS gf180mcu_fd_sc_mcu7t5v0__fill_2
XTAP_TAPCELL_ROW_13_207 VDD VSS gf180mcu_fd_sc_mcu7t5v0__filltie
XFILLER_3_422 VDD VDD VSS VSS gf180mcu_fd_sc_mcu7t5v0__fillcap_8
XFILLER_19_389 VDD VDD VSS VSS gf180mcu_fd_sc_mcu7t5v0__fill_2
Xload_slew33 _699_/RN _700_/RN VDD VDD VSS VSS gf180mcu_fd_sc_mcu7t5v0__clkbuf_3
X_309_ _684_/Q _512_/A1 VDD VDD VSS VSS gf180mcu_fd_sc_mcu7t5v0__clkinv_1
XFILLER_41_2 VDD VDD VSS VSS gf180mcu_fd_sc_mcu7t5v0__fillcap_32
XFILLER_37_142 VDD VDD VSS VSS gf180mcu_fd_sc_mcu7t5v0__fillcap_8
XFILLER_37_186 VDD VDD VSS VSS gf180mcu_fd_sc_mcu7t5v0__fillcap_4
XFILLER_52_101 VDD VDD VSS VSS gf180mcu_fd_sc_mcu7t5v0__fillcap_4
XTAP_TAPCELL_ROW_35_343 VDD VSS gf180mcu_fd_sc_mcu7t5v0__filltie
XFILLER_0_403 VDD VDD VSS VSS gf180mcu_fd_sc_mcu7t5v0__fillcap_4
XFILLER_29_77 VDD VDD VSS VSS gf180mcu_fd_sc_mcu7t5v0__fill_2
XFILLER_29_88 VDD VDD VSS VSS gf180mcu_fd_sc_mcu7t5v0__fillcap_4
XFILLER_48_429 VDD VDD VSS VSS gf180mcu_fd_sc_mcu7t5v0__fill_1
Xhold66 _670_/Q _318_/I VDD VDD VSS VSS gf180mcu_fd_sc_mcu7t5v0__dlyc_1
X_660_ _660_/D _693_/RN _693_/CLK _660_/Q VDD VDD VSS VSS gf180mcu_fd_sc_mcu7t5v0__dffrnq_1
X_591_ _601_/I _618_/RN VDD VDD VSS VSS gf180mcu_fd_sc_mcu7t5v0__clkinv_1
XTAP_TAPCELL_ROW_58_479 VDD VSS gf180mcu_fd_sc_mcu7t5v0__filltie
XTAP_TAPCELL_ROW_41_379 VDD VSS gf180mcu_fd_sc_mcu7t5v0__filltie
XFILLER_6_37 VDD VDD VSS VSS gf180mcu_fd_sc_mcu7t5v0__fillcap_16
XTAP_TAPCELL_ROW_49_424 VDD VSS gf180mcu_fd_sc_mcu7t5v0__filltie
XFILLER_19_142 VDD VDD VSS VSS gf180mcu_fd_sc_mcu7t5v0__fillcap_8
Xu_core.delay_paths.u_trc3.gen_inv_stage\[13\].inv u_core.delay_paths.u_trc3.gen_inv_stage\[13\].inv/I
+ u_core.delay_paths.u_trc3.gen_inv_stage\[14\].inv/I VDD VDD VSS VSS gf180mcu_fd_sc_mcu7t5v0__inv_1
XFILLER_30_351 VDD VDD VSS VSS gf180mcu_fd_sc_mcu7t5v0__fill_1
XFILLER_30_384 VDD VDD VSS VSS gf180mcu_fd_sc_mcu7t5v0__fill_1
Xu_core.delay_paths.u_trc3.gen_inv_stage\[28\].inv u_core.delay_paths.u_trc3.gen_inv_stage\[28\].inv/I
+ u_core.delay_paths.u_trc3.gen_inv_stage\[29\].inv/I VDD VDD VSS VSS gf180mcu_fd_sc_mcu7t5v0__inv_1
XTAP_TAPCELL_ROW_32_324 VDD VSS gf180mcu_fd_sc_mcu7t5v0__filltie
XFILLER_0_200 VDD VDD VSS VSS gf180mcu_fd_sc_mcu7t5v0__fillcap_4
X_643_ _643_/D _695_/RN _695_/CLK _643_/Q VDD VDD VSS VSS gf180mcu_fd_sc_mcu7t5v0__dffrnq_1
X_574_ _574_/A1 _571_/Z _574_/A3 _574_/B _659_/D VDD VDD VSS VSS gf180mcu_fd_sc_mcu7t5v0__oai31_1
XTAP_TAPCELL_ROW_46_405 VDD VSS gf180mcu_fd_sc_mcu7t5v0__filltie
XFILLER_8_366 VDD VDD VSS VSS gf180mcu_fd_sc_mcu7t5v0__fillcap_8
XFILLER_30_181 VDD VDD VSS VSS gf180mcu_fd_sc_mcu7t5v0__fill_1
XFILLER_30_192 VDD VDD VSS VSS gf180mcu_fd_sc_mcu7t5v0__fillcap_4
XTAP_TAPCELL_ROW_60_496 VDD VSS gf180mcu_fd_sc_mcu7t5v0__filltie
XFILLER_26_34 VDD VDD VSS VSS gf180mcu_fd_sc_mcu7t5v0__fill_1
XFILLER_45_207 VDD VDD VSS VSS gf180mcu_fd_sc_mcu7t5v0__fill_2
XFILLER_5_303 VDD VDD VSS VSS gf180mcu_fd_sc_mcu7t5v0__fill_2
XFILLER_3_38 VDD VDD VSS VSS gf180mcu_fd_sc_mcu7t5v0__fill_2
Xu_core.delay_paths.u_trc2.gen_inv_stage\[52\].inv u_core.delay_paths.u_trc2.gen_inv_stage\[52\].inv/I
+ u_core.delay_paths.u_trc2.gen_inv_stage\[53\].inv/I VDD VDD VSS VSS gf180mcu_fd_sc_mcu7t5v0__inv_1
Xu_core.delay_paths.u_trc2.gen_inv_stage\[67\].inv u_core.delay_paths.u_trc2.gen_inv_stage\[67\].inv/I
+ u_core.delay_paths.u_trc2.gen_inv_stage\[68\].inv/I VDD VDD VSS VSS gf180mcu_fd_sc_mcu7t5v0__inv_1
XFILLER_29_292 VDD VDD VSS VSS gf180mcu_fd_sc_mcu7t5v0__fill_1
X_626_ _626_/D _626_/RN _626_/CLK _626_/Q VDD VDD VSS VSS gf180mcu_fd_sc_mcu7t5v0__dffrnq_1
X_557_ _661_/Q _660_/Q _556_/Z _577_/A1 VDD VDD VSS VSS gf180mcu_fd_sc_mcu7t5v0__nor3_1
X_488_ _497_/A1 _484_/B _488_/B1 _494_/A1 _668_/D VDD VDD VSS VSS gf180mcu_fd_sc_mcu7t5v0__aoi22_1
XFILLER_4_391 VDD VDD VSS VSS gf180mcu_fd_sc_mcu7t5v0__fillcap_16
XFILLER_10_107 VDD VDD VSS VSS gf180mcu_fd_sc_mcu7t5v0__fill_2
XFILLER_12_69 VDD VDD VSS VSS gf180mcu_fd_sc_mcu7t5v0__fillcap_8
XFILLER_58_387 VDD VDD VSS VSS gf180mcu_fd_sc_mcu7t5v0__fillcap_32
X_411_ _638_/Q _663_/Q _666_/Q _411_/C _413_/B VDD VDD VSS VSS gf180mcu_fd_sc_mcu7t5v0__aoi211_1
X_342_ _350_/A1 _350_/A2 _342_/B _352_/B2 VDD VDD VSS VSS gf180mcu_fd_sc_mcu7t5v0__oai21_1
XFILLER_41_298 VDD VDD VSS VSS gf180mcu_fd_sc_mcu7t5v0__fill_2
XFILLER_1_361 VDD VDD VSS VSS gf180mcu_fd_sc_mcu7t5v0__fillcap_4
Xu_core.delay_paths.u_trc1.gen_inv_stage\[107\].inv u_core.delay_paths.u_trc1.gen_inv_stage\[107\].inv/I
+ u_core.delay_paths.u_trc1.gen_inv_stage\[108\].inv/I VDD VDD VSS VSS gf180mcu_fd_sc_mcu7t5v0__inv_1
X_609_ _609_/D wire28/Z _700_/CLK _609_/Q VDD VDD VSS VSS gf180mcu_fd_sc_mcu7t5v0__dffrnq_1
XTAP_TAPCELL_ROW_19_246 VDD VSS gf180mcu_fd_sc_mcu7t5v0__filltie
XFILLER_32_210 VDD VDD VSS VSS gf180mcu_fd_sc_mcu7t5v0__fill_1
XTAP_TAPCELL_ROW_27_290 VDD VSS gf180mcu_fd_sc_mcu7t5v0__filltie
XTAP_TAPCELL_ROW_10_190 VDD VSS gf180mcu_fd_sc_mcu7t5v0__filltie
XFILLER_55_346 VDD VDD VSS VSS gf180mcu_fd_sc_mcu7t5v0__fillcap_4
Xu_core.delay_paths.u_trc1.gen_inv_stage\[91\].inv u_core.delay_paths.u_trc1.gen_inv_stage\[91\].inv/I
+ u_core.delay_paths.u_trc1.gen_inv_stage\[92\].inv/I VDD VDD VSS VSS gf180mcu_fd_sc_mcu7t5v0__inv_1
Xclkbuf_4_11__f_iCLK clkbuf_0_iCLK/Z _694_/CLK VDD VDD VSS VSS gf180mcu_fd_sc_mcu7t5v0__clkbuf_16
Xu_core.delay_paths.u_trc1.gen_inv_stage\[44\].inv u_core.delay_paths.u_trc1.gen_inv_stage\[44\].inv/I
+ u_core.delay_paths.u_trc1.gen_inv_stage\[45\].inv/I VDD VDD VSS VSS gf180mcu_fd_sc_mcu7t5v0__inv_1
Xmax_cap9 _565_/C _574_/A1 VDD VDD VSS VSS gf180mcu_fd_sc_mcu7t5v0__clkbuf_2
Xu_core.delay_paths.u_trc1.gen_inv_stage\[59\].inv u_core.delay_paths.u_trc1.gen_inv_stage\[59\].inv/I
+ u_core.delay_paths.u_trc1.gen_inv_stage\[60\].inv/I VDD VDD VSS VSS gf180mcu_fd_sc_mcu7t5v0__inv_1
X_325_ _629_/Q _449_/A1 VDD VDD VSS VSS gf180mcu_fd_sc_mcu7t5v0__clkinv_1
XTAP_TAPCELL_ROW_16_227 VDD VSS gf180mcu_fd_sc_mcu7t5v0__filltie
XFILLER_13_90 VDD VDD VSS VSS gf180mcu_fd_sc_mcu7t5v0__fill_1
XFILLER_6_420 VDD VDD VSS VSS gf180mcu_fd_sc_mcu7t5v0__fillcap_8
XFILLER_34_34 VDD VDD VSS VSS gf180mcu_fd_sc_mcu7t5v0__fill_1
XFILLER_34_45 VDD VDD VSS VSS gf180mcu_fd_sc_mcu7t5v0__fillcap_4
XFILLER_43_349 VDD VDD VSS VSS gf180mcu_fd_sc_mcu7t5v0__fill_1
XTAP_TAPCELL_ROW_13_208 VDD VSS gf180mcu_fd_sc_mcu7t5v0__filltie
XFILLER_11_279 VDD VDD VSS VSS gf180mcu_fd_sc_mcu7t5v0__fill_1
Xclkload0 _700_/CLK clkload0/Z VDD VDD VSS VSS gf180mcu_fd_sc_mcu7t5v0__clkbuf_2
XFILLER_46_143 VDD VDD VSS VSS gf180mcu_fd_sc_mcu7t5v0__fill_1
XFILLER_46_154 VDD VDD VSS VSS gf180mcu_fd_sc_mcu7t5v0__fill_1
XPHY_EDGE_ROW_28_Left_89 VDD VSS gf180mcu_fd_sc_mcu7t5v0__endcap
X_308_ _685_/Q _514_/A1 VDD VDD VSS VSS gf180mcu_fd_sc_mcu7t5v0__clkinv_1
XFILLER_34_2 VDD VDD VSS VSS gf180mcu_fd_sc_mcu7t5v0__fillcap_32
Xu_core.delay_paths.u_trc0.gen_inv_stage\[147\].inv u_core.delay_paths.u_trc0.gen_inv_stage\[147\].inv/I
+ u_core.delay_paths.u_trc0.gen_inv_stage\[148\].inv/I VDD VDD VSS VSS gf180mcu_fd_sc_mcu7t5v0__inv_1
Xu_core.delay_paths.u_trc0.gen_inv_stage\[132\].inv u_core.delay_paths.u_trc0.gen_inv_stage\[132\].inv/I
+ u_core.delay_paths.u_trc0.gen_inv_stage\[133\].inv/I VDD VDD VSS VSS gf180mcu_fd_sc_mcu7t5v0__inv_1
XFILLER_1_60 VDD VDD VSS VSS gf180mcu_fd_sc_mcu7t5v0__fill_2
XFILLER_37_154 VDD VDD VSS VSS gf180mcu_fd_sc_mcu7t5v0__fillcap_8
XFILLER_25_349 VDD VDD VSS VSS gf180mcu_fd_sc_mcu7t5v0__fill_1
XFILLER_0_426 VDD VDD VSS VSS gf180mcu_fd_sc_mcu7t5v0__fillcap_4
XFILLER_20_69 VDD VDD VSS VSS gf180mcu_fd_sc_mcu7t5v0__fillcap_16
XFILLER_29_34 VDD VDD VSS VSS gf180mcu_fd_sc_mcu7t5v0__fill_2
XFILLER_48_419 VDD VDD VSS VSS gf180mcu_fd_sc_mcu7t5v0__fillcap_8
Xu_core.delay_paths.u_trc0.gen_inv_stage\[83\].inv u_core.delay_paths.u_trc0.gen_inv_stage\[83\].inv/I
+ u_core.delay_paths.u_trc0.gen_inv_stage\[84\].inv/I VDD VDD VSS VSS gf180mcu_fd_sc_mcu7t5v0__inv_2
Xhold56 _619_/Q _620_/D VDD VDD VSS VSS gf180mcu_fd_sc_mcu7t5v0__dlyc_1
Xu_core.delay_paths.u_trc0.gen_inv_stage\[21\].inv u_core.delay_paths.u_trc0.gen_inv_stage\[21\].inv/I
+ u_core.delay_paths.u_trc0.gen_inv_stage\[22\].inv/I VDD VDD VSS VSS gf180mcu_fd_sc_mcu7t5v0__inv_1
Xu_core.delay_paths.u_trc0.gen_inv_stage\[98\].inv u_core.delay_paths.u_trc0.gen_inv_stage\[98\].inv/I
+ u_core.delay_paths.u_trc0.gen_inv_stage\[99\].inv/I VDD VDD VSS VSS gf180mcu_fd_sc_mcu7t5v0__inv_1
Xhold67 _652_/Q _299_/I VDD VDD VSS VSS gf180mcu_fd_sc_mcu7t5v0__dlyc_1
X_590_ _601_/I _617_/RN VDD VDD VSS VSS gf180mcu_fd_sc_mcu7t5v0__clkinv_1
Xu_core.delay_paths.u_trc0.gen_inv_stage\[36\].inv u_core.delay_paths.u_trc0.gen_inv_stage\[36\].inv/I
+ u_core.delay_paths.u_trc0.gen_inv_stage\[37\].inv/I VDD VDD VSS VSS gf180mcu_fd_sc_mcu7t5v0__inv_1
XTAP_TAPCELL_ROW_49_425 VDD VSS gf180mcu_fd_sc_mcu7t5v0__filltie
XFILLER_22_308 VDD VDD VSS VSS gf180mcu_fd_sc_mcu7t5v0__fill_2
XTAP_TAPCELL_ROW_32_325 VDD VSS gf180mcu_fd_sc_mcu7t5v0__filltie
XFILLER_25_124 VDD VDD VSS VSS gf180mcu_fd_sc_mcu7t5v0__fill_2
XFILLER_25_135 VDD VDD VSS VSS gf180mcu_fd_sc_mcu7t5v0__fillcap_4
XFILLER_53_422 VDD VDD VSS VSS gf180mcu_fd_sc_mcu7t5v0__fillcap_8
XFILLER_13_319 VDD VDD VSS VSS gf180mcu_fd_sc_mcu7t5v0__fill_2
XFILLER_21_352 VDD VDD VSS VSS gf180mcu_fd_sc_mcu7t5v0__fill_1
XFILLER_21_374 VDD VDD VSS VSS gf180mcu_fd_sc_mcu7t5v0__fill_2
XFILLER_21_385 VDD VDD VSS VSS gf180mcu_fd_sc_mcu7t5v0__fill_1
XFILLER_40_127 VDD VDD VSS VSS gf180mcu_fd_sc_mcu7t5v0__fill_1
X_642_ _642_/D _642_/RN _695_/CLK _642_/Q VDD VDD VSS VSS gf180mcu_fd_sc_mcu7t5v0__dffrnq_1
XTAP_TAPCELL_ROW_46_406 VDD VSS gf180mcu_fd_sc_mcu7t5v0__filltie
XFILLER_16_168 VDD VDD VSS VSS gf180mcu_fd_sc_mcu7t5v0__fillcap_4
X_573_ _659_/Q _574_/A1 _574_/B VDD VDD VSS VSS gf180mcu_fd_sc_mcu7t5v0__nand2_1
XPHY_EDGE_ROW_19_Right_19 VDD VSS gf180mcu_fd_sc_mcu7t5v0__endcap
XFILLER_8_378 VDD VDD VSS VSS gf180mcu_fd_sc_mcu7t5v0__fill_2
XPHY_EDGE_ROW_28_Right_28 VDD VSS gf180mcu_fd_sc_mcu7t5v0__endcap
XFILLER_35_422 VDD VDD VSS VSS gf180mcu_fd_sc_mcu7t5v0__fillcap_8
XFILLER_47_282 VDD VDD VSS VSS gf180mcu_fd_sc_mcu7t5v0__fillcap_64
XPHY_EDGE_ROW_37_Right_37 VDD VSS gf180mcu_fd_sc_mcu7t5v0__endcap
XTAP_TAPCELL_ROW_60_497 VDD VSS gf180mcu_fd_sc_mcu7t5v0__filltie
XPHY_EDGE_ROW_46_Right_46 VDD VSS gf180mcu_fd_sc_mcu7t5v0__endcap
XPHY_EDGE_ROW_15_Left_76 VDD VSS gf180mcu_fd_sc_mcu7t5v0__endcap
XPHY_EDGE_ROW_55_Right_55 VDD VSS gf180mcu_fd_sc_mcu7t5v0__endcap
XFILLER_42_34 VDD VDD VSS VSS gf180mcu_fd_sc_mcu7t5v0__fill_1
Xu_core.delay_paths.u_trc3.gen_inv_stage\[12\].inv u_core.delay_paths.u_trc3.gen_inv_stage\[12\].inv/I
+ u_core.delay_paths.u_trc3.gen_inv_stage\[13\].inv/I VDD VDD VSS VSS gf180mcu_fd_sc_mcu7t5v0__inv_1
XFILLER_29_282 VDD VDD VSS VSS gf180mcu_fd_sc_mcu7t5v0__fillcap_8
Xu_core.delay_paths.u_trc3.gen_inv_stage\[27\].inv u_core.delay_paths.u_trc3.gen_inv_stage\[27\].inv/I
+ u_core.delay_paths.u_trc3.gen_inv_stage\[28\].inv/I VDD VDD VSS VSS gf180mcu_fd_sc_mcu7t5v0__inv_1
X_625_ _625_/D _625_/RN _626_/CLK _625_/Q VDD VDD VSS VSS gf180mcu_fd_sc_mcu7t5v0__dffrnq_1
X_556_ _658_/Q _659_/Q _556_/Z VDD VDD VSS VSS gf180mcu_fd_sc_mcu7t5v0__or2_1
X_487_ _494_/A1 _488_/B1 _490_/A2 VDD VDD VSS VSS gf180mcu_fd_sc_mcu7t5v0__nand2_1
XFILLER_12_37 VDD VDD VSS VSS gf180mcu_fd_sc_mcu7t5v0__fillcap_32
XFILLER_37_34 VDD VDD VSS VSS gf180mcu_fd_sc_mcu7t5v0__fill_2
XFILLER_58_311 VDD VDD VSS VSS gf180mcu_fd_sc_mcu7t5v0__fillcap_4
XFILLER_14_425 VDD VDD VSS VSS gf180mcu_fd_sc_mcu7t5v0__fillcap_4
XFILLER_53_66 VDD VDD VSS VSS gf180mcu_fd_sc_mcu7t5v0__fillcap_4
X_410_ _663_/Q _664_/Q _411_/C VDD VDD VSS VSS gf180mcu_fd_sc_mcu7t5v0__and2_1
X_341_ _350_/A1 _350_/A2 _342_/B _341_/Z VDD VDD VSS VSS gf180mcu_fd_sc_mcu7t5v0__or3_1
XFILLER_5_134 VDD VDD VSS VSS gf180mcu_fd_sc_mcu7t5v0__fillcap_4
XFILLER_17_241 VDD VDD VSS VSS gf180mcu_fd_sc_mcu7t5v0__fillcap_4
X_608_ _608_/D wire28/Z _700_/CLK _722_/I VDD VDD VSS VSS gf180mcu_fd_sc_mcu7t5v0__dffrnq_1
XTAP_TAPCELL_ROW_19_247 VDD VSS gf180mcu_fd_sc_mcu7t5v0__filltie
X_539_ _643_/Q _648_/Q _539_/S _648_/D VDD VDD VSS VSS gf180mcu_fd_sc_mcu7t5v0__mux2_2
XTAP_TAPCELL_ROW_27_291 VDD VSS gf180mcu_fd_sc_mcu7t5v0__filltie
XTAP_TAPCELL_ROW_10_191 VDD VSS gf180mcu_fd_sc_mcu7t5v0__filltie
XFILLER_23_288 VDD VDD VSS VSS gf180mcu_fd_sc_mcu7t5v0__fill_1
Xu_core.delay_paths.u_trc2.gen_inv_stage\[51\].inv u_core.delay_paths.u_trc2.gen_inv_stage\[51\].inv/I
+ u_core.delay_paths.u_trc2.gen_inv_stage\[52\].inv/I VDD VDD VSS VSS gf180mcu_fd_sc_mcu7t5v0__inv_1
Xu_core.delay_paths.u_trc2.gen_inv_stage\[66\].inv u_core.delay_paths.u_trc2.gen_inv_stage\[66\].inv/I
+ u_core.delay_paths.u_trc2.gen_inv_stage\[67\].inv/I VDD VDD VSS VSS gf180mcu_fd_sc_mcu7t5v0__inv_1
XPHY_EDGE_ROW_45_Left_106 VDD VSS gf180mcu_fd_sc_mcu7t5v0__endcap
XFILLER_14_200 VDD VDD VSS VSS gf180mcu_fd_sc_mcu7t5v0__fill_1
XFILLER_48_77 VDD VDD VSS VSS gf180mcu_fd_sc_mcu7t5v0__fillcap_16
XTAP_TAPCELL_ROW_16_228 VDD VSS gf180mcu_fd_sc_mcu7t5v0__filltie
XFILLER_14_233 VDD VDD VSS VSS gf180mcu_fd_sc_mcu7t5v0__fillcap_8
Xu_core.delay_paths.u_trc2.gen_inv_stage\[19\].inv u_core.delay_paths.u_trc2.gen_inv_stage\[19\].inv/I
+ u_core.delay_paths.u_trc2.gen_inv_stage\[20\].inv/I VDD VDD VSS VSS gf180mcu_fd_sc_mcu7t5v0__inv_1
X_324_ _637_/Q _527_/A1 VDD VDD VSS VSS gf180mcu_fd_sc_mcu7t5v0__clkinv_1
XTAP_TAPCELL_ROW_24_272 VDD VSS gf180mcu_fd_sc_mcu7t5v0__filltie
XPHY_EDGE_ROW_54_Left_115 VDD VSS gf180mcu_fd_sc_mcu7t5v0__endcap
XFILLER_37_347 VDD VDD VSS VSS gf180mcu_fd_sc_mcu7t5v0__fill_2
XFILLER_52_317 VDD VDD VSS VSS gf180mcu_fd_sc_mcu7t5v0__fillcap_64
XFILLER_20_225 VDD VDD VSS VSS gf180mcu_fd_sc_mcu7t5v0__fillcap_8
XFILLER_20_247 VDD VDD VSS VSS gf180mcu_fd_sc_mcu7t5v0__fillcap_16
XFILLER_28_314 VDD VDD VSS VSS gf180mcu_fd_sc_mcu7t5v0__fill_1
XFILLER_28_325 VDD VDD VSS VSS gf180mcu_fd_sc_mcu7t5v0__fill_2
XFILLER_11_236 VDD VDD VSS VSS gf180mcu_fd_sc_mcu7t5v0__fill_1
Xu_core.delay_paths.u_trc1.gen_inv_stage\[106\].inv u_core.delay_paths.u_trc1.gen_inv_stage\[106\].inv/I
+ u_core.delay_paths.u_trc1.gen_inv_stage\[107\].inv/I VDD VDD VSS VSS gf180mcu_fd_sc_mcu7t5v0__inv_1
Xclkload1 _669_/CLK clkload1/Z VDD VDD VSS VSS gf180mcu_fd_sc_mcu7t5v0__clkbuf_2
XTAP_TAPCELL_ROW_13_209 VDD VSS gf180mcu_fd_sc_mcu7t5v0__filltie
XFILLER_50_34 VDD VDD VSS VSS gf180mcu_fd_sc_mcu7t5v0__fill_1
Xclkbuf_4_9__f_iCLK clkbuf_0_iCLK/Z _688_/CLK VDD VDD VSS VSS gf180mcu_fd_sc_mcu7t5v0__clkbuf_16
XPHY_EDGE_ROW_3_Left_64 VDD VSS gf180mcu_fd_sc_mcu7t5v0__endcap
XFILLER_46_177 VDD VDD VSS VSS gf180mcu_fd_sc_mcu7t5v0__fillcap_16
XFILLER_42_383 VDD VDD VSS VSS gf180mcu_fd_sc_mcu7t5v0__fill_2
X_307_ _680_/Q _507_/A1 VDD VDD VSS VSS gf180mcu_fd_sc_mcu7t5v0__clkinv_1
XFILLER_27_2 VDD VDD VSS VSS gf180mcu_fd_sc_mcu7t5v0__fillcap_64
XFILLER_1_72 VDD VDD VSS VSS gf180mcu_fd_sc_mcu7t5v0__fillcap_4
XFILLER_37_133 VDD VDD VSS VSS gf180mcu_fd_sc_mcu7t5v0__fillcap_4
XFILLER_37_166 VDD VDD VSS VSS gf180mcu_fd_sc_mcu7t5v0__fill_2
XFILLER_37_177 VDD VDD VSS VSS gf180mcu_fd_sc_mcu7t5v0__fill_2
Xu_core.delay_paths.u_trc1.gen_inv_stage\[90\].inv u_core.delay_paths.u_trc1.gen_inv_stage\[90\].inv/I
+ u_core.delay_paths.u_trc1.gen_inv_stage\[91\].inv/I VDD VDD VSS VSS gf180mcu_fd_sc_mcu7t5v0__inv_1
XFILLER_33_372 VDD VDD VSS VSS gf180mcu_fd_sc_mcu7t5v0__fillcap_4
XFILLER_20_37 VDD VDD VSS VSS gf180mcu_fd_sc_mcu7t5v0__fillcap_32
Xu_core.delay_paths.u_trc1.gen_inv_stage\[43\].inv u_core.delay_paths.u_trc1.gen_inv_stage\[43\].inv/I
+ u_core.delay_paths.u_trc1.gen_inv_stage\[44\].inv/I VDD VDD VSS VSS gf180mcu_fd_sc_mcu7t5v0__inv_1
Xu_core.delay_paths.u_trc1.gen_inv_stage\[58\].inv u_core.delay_paths.u_trc1.gen_inv_stage\[58\].inv/I
+ u_core.delay_paths.u_trc1.gen_inv_stage\[59\].inv/I VDD VDD VSS VSS gf180mcu_fd_sc_mcu7t5v0__inv_1
Xhold68 _683_/Q hold68/Z VDD VDD VSS VSS gf180mcu_fd_sc_mcu7t5v0__dlyc_1
Xhold57 _703_/Q _689_/D VDD VDD VSS VSS gf180mcu_fd_sc_mcu7t5v0__dlyc_1
XFILLER_16_317 VDD VDD VSS VSS gf180mcu_fd_sc_mcu7t5v0__fillcap_4
XFILLER_45_34 VDD VDD VSS VSS gf180mcu_fd_sc_mcu7t5v0__fill_1
XFILLER_3_287 VDD VDD VSS VSS gf180mcu_fd_sc_mcu7t5v0__fill_2
XFILLER_19_100 VDD VDD VSS VSS gf180mcu_fd_sc_mcu7t5v0__fill_2
XFILLER_19_188 VDD VDD VSS VSS gf180mcu_fd_sc_mcu7t5v0__fill_2
XTAP_TAPCELL_ROW_57_470 VDD VSS gf180mcu_fd_sc_mcu7t5v0__filltie
XTAP_TAPCELL_ROW_49_426 VDD VSS gf180mcu_fd_sc_mcu7t5v0__filltie
XFILLER_30_342 VDD VDD VSS VSS gf180mcu_fd_sc_mcu7t5v0__fill_2
XTAP_TAPCELL_ROW_40_370 VDD VSS gf180mcu_fd_sc_mcu7t5v0__filltie
XFILLER_57_206 VDD VDD VSS VSS gf180mcu_fd_sc_mcu7t5v0__fillcap_4
XFILLER_25_158 VDD VDD VSS VSS gf180mcu_fd_sc_mcu7t5v0__fill_2
XFILLER_21_342 VDD VDD VSS VSS gf180mcu_fd_sc_mcu7t5v0__fillcap_8
Xu_core.delay_paths.u_trc0.gen_inv_stage\[131\].inv u_core.delay_paths.u_trc0.gen_inv_stage\[131\].inv/I
+ u_core.delay_paths.u_trc0.gen_inv_stage\[132\].inv/I VDD VDD VSS VSS gf180mcu_fd_sc_mcu7t5v0__inv_1
X_641_ _641_/D _687_/RN _644_/CLK _641_/Q VDD VDD VSS VSS gf180mcu_fd_sc_mcu7t5v0__dffrnq_1
X_572_ _581_/A1 _556_/Z _572_/B _574_/A3 VDD VDD VSS VSS gf180mcu_fd_sc_mcu7t5v0__aoi21_1
XTAP_TAPCELL_ROW_46_407 VDD VSS gf180mcu_fd_sc_mcu7t5v0__filltie
XFILLER_12_353 VDD VDD VSS VSS gf180mcu_fd_sc_mcu7t5v0__fillcap_4
XFILLER_16_147 VDD VDD VSS VSS gf180mcu_fd_sc_mcu7t5v0__fillcap_8
XFILLER_31_139 VDD VDD VSS VSS gf180mcu_fd_sc_mcu7t5v0__fill_1
Xu_core.delay_paths.u_trc0.gen_inv_stage\[146\].inv u_core.delay_paths.u_trc0.gen_inv_stage\[146\].inv/I
+ u_core.delay_paths.u_trc0.gen_inv_stage\[147\].inv/I VDD VDD VSS VSS gf180mcu_fd_sc_mcu7t5v0__inv_1
Xu_core.delay_paths.u_trc0.gen_inv_stage\[82\].inv u_core.delay_paths.u_trc0.gen_inv_stage\[82\].inv/I
+ u_core.delay_paths.u_trc0.gen_inv_stage\[83\].inv/I VDD VDD VSS VSS gf180mcu_fd_sc_mcu7t5v0__inv_2
Xu_core.delay_paths.u_trc0.gen_inv_stage\[97\].inv u_core.delay_paths.u_trc0.gen_inv_stage\[97\].inv/I
+ u_core.delay_paths.u_trc0.gen_inv_stage\[98\].inv/I VDD VDD VSS VSS gf180mcu_fd_sc_mcu7t5v0__inv_1
XTAP_TAPCELL_ROW_60_498 VDD VSS gf180mcu_fd_sc_mcu7t5v0__filltie
Xu_core.delay_paths.u_trc0.gen_inv_stage\[20\].inv u_core.delay_paths.u_trc0.gen_inv_stage\[20\].inv/I
+ u_core.delay_paths.u_trc0.gen_inv_stage\[21\].inv/I VDD VDD VSS VSS gf180mcu_fd_sc_mcu7t5v0__inv_1
XFILLER_45_209 VDD VDD VSS VSS gf180mcu_fd_sc_mcu7t5v0__fill_1
Xu_core.delay_paths.u_trc0.gen_inv_stage\[35\].inv u_core.delay_paths.u_trc0.gen_inv_stage\[35\].inv/I
+ u_core.delay_paths.u_trc0.gen_inv_stage\[36\].inv/I VDD VDD VSS VSS gf180mcu_fd_sc_mcu7t5v0__inv_1
XFILLER_26_69 VDD VDD VSS VSS gf180mcu_fd_sc_mcu7t5v0__fillcap_8
XFILLER_21_183 VDD VDD VSS VSS gf180mcu_fd_sc_mcu7t5v0__fillcap_16
XTAP_TAPCELL_ROW_8_176 VDD VSS gf180mcu_fd_sc_mcu7t5v0__filltie
XFILLER_44_242 VDD VDD VSS VSS gf180mcu_fd_sc_mcu7t5v0__fill_2
X_624_ _624_/D _624_/RN _626_/CLK _624_/Q VDD VDD VSS VSS gf180mcu_fd_sc_mcu7t5v0__dffrnq_1
X_555_ _555_/I _561_/B VDD VDD VSS VSS gf180mcu_fd_sc_mcu7t5v0__clkinv_1
XFILLER_8_143 VDD VDD VSS VSS gf180mcu_fd_sc_mcu7t5v0__fillcap_32
X_486_ _492_/A1 _486_/A2 _488_/B1 VDD VDD VSS VSS gf180mcu_fd_sc_mcu7t5v0__nand2_1
XPHY_EDGE_ROW_32_Left_93 VDD VSS gf180mcu_fd_sc_mcu7t5v0__endcap
XFILLER_4_382 VDD VDD VSS VSS gf180mcu_fd_sc_mcu7t5v0__fill_2
XFILLER_2_308 VDD VDD VSS VSS gf180mcu_fd_sc_mcu7t5v0__fill_1
XFILLER_41_212 VDD VDD VSS VSS gf180mcu_fd_sc_mcu7t5v0__fillcap_8
XFILLER_41_267 VDD VDD VSS VSS gf180mcu_fd_sc_mcu7t5v0__fillcap_4
XFILLER_41_278 VDD VDD VSS VSS gf180mcu_fd_sc_mcu7t5v0__fill_2
X_340_ _527_/A1 _655_/Q _342_/B VDD VDD VSS VSS gf180mcu_fd_sc_mcu7t5v0__xor2_1
XFILLER_1_352 VDD VDD VSS VSS gf180mcu_fd_sc_mcu7t5v0__fill_1
X_607_ _607_/D wire28/Z _705_/CLK _607_/Q VDD VDD VSS VSS gf180mcu_fd_sc_mcu7t5v0__dffrnq_1
X_538_ _642_/Q _647_/Q _539_/S _647_/D VDD VDD VSS VSS gf180mcu_fd_sc_mcu7t5v0__mux2_2
XTAP_TAPCELL_ROW_27_292 VDD VSS gf180mcu_fd_sc_mcu7t5v0__filltie
X_469_ _663_/Q _481_/B _470_/B VDD VDD VSS VSS gf180mcu_fd_sc_mcu7t5v0__nand2_1
XFILLER_4_94 VDD VDD VSS VSS gf180mcu_fd_sc_mcu7t5v0__fill_2
XFILLER_57_2 VDD VDD VSS VSS gf180mcu_fd_sc_mcu7t5v0__fillcap_64
XTAP_TAPCELL_ROW_10_192 VDD VSS gf180mcu_fd_sc_mcu7t5v0__filltie
XFILLER_23_212 VDD VDD VSS VSS gf180mcu_fd_sc_mcu7t5v0__fillcap_8
Xu_core.delay_paths.u_trc3.gen_inv_stage\[11\].inv u_core.delay_paths.u_trc3.gen_inv_stage\[11\].inv/I
+ u_core.delay_paths.u_trc3.gen_inv_stage\[12\].inv/I VDD VDD VSS VSS gf180mcu_fd_sc_mcu7t5v0__inv_1
XFILLER_2_127 VDD VDD VSS VSS gf180mcu_fd_sc_mcu7t5v0__fillcap_8
Xu_core.delay_paths.u_trc3.gen_inv_stage\[26\].inv u_core.delay_paths.u_trc3.gen_inv_stage\[26\].inv/I
+ u_core.delay_paths.u_trc3.gen_inv_stage\[27\].inv/I VDD VDD VSS VSS gf180mcu_fd_sc_mcu7t5v0__inv_1
XFILLER_2_149 VDD VDD VSS VSS gf180mcu_fd_sc_mcu7t5v0__fillcap_16
XFILLER_48_34 VDD VDD VSS VSS gf180mcu_fd_sc_mcu7t5v0__fill_1
XFILLER_54_381 VDD VDD VSS VSS gf180mcu_fd_sc_mcu7t5v0__fillcap_4
Xclkbuf_4_5__f_iCLK clkbuf_0_iCLK/Z _685_/CLK VDD VDD VSS VSS gf180mcu_fd_sc_mcu7t5v0__clkbuf_16
XTAP_TAPCELL_ROW_16_229 VDD VSS gf180mcu_fd_sc_mcu7t5v0__filltie
X_323_ _628_/Q _446_/A1 VDD VDD VSS VSS gf180mcu_fd_sc_mcu7t5v0__clkinv_1
XTAP_TAPCELL_ROW_24_273 VDD VSS gf180mcu_fd_sc_mcu7t5v0__filltie
XFILLER_37_304 VDD VDD VSS VSS gf180mcu_fd_sc_mcu7t5v0__fillcap_8
XFILLER_49_142 VDD VDD VSS VSS gf180mcu_fd_sc_mcu7t5v0__fillcap_64
XFILLER_18_37 VDD VDD VSS VSS gf180mcu_fd_sc_mcu7t5v0__fillcap_64
Xclkload2 _705_/CLK clkload2/Z VDD VDD VSS VSS gf180mcu_fd_sc_mcu7t5v0__clkbuf_2
XTAP_TAPCELL_ROW_21_254 VDD VSS gf180mcu_fd_sc_mcu7t5v0__filltie
XFILLER_59_66 VDD VDD VSS VSS gf180mcu_fd_sc_mcu7t5v0__fillcap_4
XFILLER_19_348 VDD VDD VSS VSS gf180mcu_fd_sc_mcu7t5v0__fill_2
XFILLER_34_307 VDD VDD VSS VSS gf180mcu_fd_sc_mcu7t5v0__fillcap_8
Xload_slew36 _642_/RN _687_/RN VDD VDD VSS VSS gf180mcu_fd_sc_mcu7t5v0__buf_3
XFILLER_27_392 VDD VDD VSS VSS gf180mcu_fd_sc_mcu7t5v0__fillcap_16
XFILLER_42_351 VDD VDD VSS VSS gf180mcu_fd_sc_mcu7t5v0__fillcap_32
X_306_ _701_/Q _581_/A1 VDD VDD VSS VSS gf180mcu_fd_sc_mcu7t5v0__clkinv_1
XFILLER_6_263 VDD VDD VSS VSS gf180mcu_fd_sc_mcu7t5v0__fill_2
Xu_core.delay_paths.u_trc2.gen_inv_stage\[50\].inv u_core.delay_paths.u_trc2.gen_inv_stage\[50\].inv/I
+ u_core.delay_paths.u_trc2.gen_inv_stage\[51\].inv/I VDD VDD VSS VSS gf180mcu_fd_sc_mcu7t5v0__inv_1
Xu_core.delay_paths.u_trc2.gen_inv_stage\[65\].inv u_core.delay_paths.u_trc2.gen_inv_stage\[65\].inv/I
+ u_core.delay_paths.u_trc2.gen_inv_stage\[66\].inv/I VDD VDD VSS VSS gf180mcu_fd_sc_mcu7t5v0__inv_1
XTAP_TAPCELL_ROW_43_390 VDD VSS gf180mcu_fd_sc_mcu7t5v0__filltie
Xu_core.delay_paths.u_trc2.gen_inv_stage\[18\].inv u_core.delay_paths.u_trc2.gen_inv_stage\[18\].inv/I
+ u_core.delay_paths.u_trc2.gen_inv_stage\[19\].inv/I VDD VDD VSS VSS gf180mcu_fd_sc_mcu7t5v0__inv_1
Xhold69 _661_/Q _312_/I VDD VDD VSS VSS gf180mcu_fd_sc_mcu7t5v0__dlyc_1
Xhold58 _620_/Q _621_/D VDD VDD VSS VSS gf180mcu_fd_sc_mcu7t5v0__dlyc_1
XFILLER_24_384 VDD VDD VSS VSS gf180mcu_fd_sc_mcu7t5v0__fill_1
XFILLER_3_244 VDD VDD VSS VSS gf180mcu_fd_sc_mcu7t5v0__fill_2
XFILLER_3_266 VDD VDD VSS VSS gf180mcu_fd_sc_mcu7t5v0__fillcap_8
XFILLER_19_123 VDD VDD VSS VSS gf180mcu_fd_sc_mcu7t5v0__fill_2
XTAP_TAPCELL_ROW_57_471 VDD VSS gf180mcu_fd_sc_mcu7t5v0__filltie
XTAP_TAPCELL_ROW_49_427 VDD VSS gf180mcu_fd_sc_mcu7t5v0__filltie
XFILLER_30_387 VDD VDD VSS VSS gf180mcu_fd_sc_mcu7t5v0__fillcap_32
XTAP_TAPCELL_ROW_40_371 VDD VSS gf180mcu_fd_sc_mcu7t5v0__filltie
Xu_core.delay_paths.u_trc1.gen_inv_stage\[105\].inv u_core.delay_paths.u_trc1.gen_inv_stage\[105\].inv/I
+ u_core.delay_paths.u_trc1.gen_inv_stage\[106\].inv/I VDD VDD VSS VSS gf180mcu_fd_sc_mcu7t5v0__inv_1
XFILLER_25_126 VDD VDD VSS VSS gf180mcu_fd_sc_mcu7t5v0__fill_1
XFILLER_40_107 VDD VDD VSS VSS gf180mcu_fd_sc_mcu7t5v0__fill_1
XFILLER_21_376 VDD VDD VSS VSS gf180mcu_fd_sc_mcu7t5v0__fill_1
XPHY_EDGE_ROW_1_Right_1 VDD VSS gf180mcu_fd_sc_mcu7t5v0__endcap
XFILLER_56_34 VDD VDD VSS VSS gf180mcu_fd_sc_mcu7t5v0__fill_1
X_640_ _640_/D _687_/RN _644_/CLK _640_/Q VDD VDD VSS VSS gf180mcu_fd_sc_mcu7t5v0__dffrnq_1
X_571_ _581_/A1 _572_/B _571_/Z VDD VDD VSS VSS gf180mcu_fd_sc_mcu7t5v0__and2_1
XTAP_TAPCELL_ROW_46_408 VDD VSS gf180mcu_fd_sc_mcu7t5v0__filltie
XFILLER_16_159 VDD VDD VSS VSS gf180mcu_fd_sc_mcu7t5v0__fill_1
XFILLER_8_303 VDD VDD VSS VSS gf180mcu_fd_sc_mcu7t5v0__fill_2
XFILLER_8_314 VDD VDD VSS VSS gf180mcu_fd_sc_mcu7t5v0__fill_1
XTAP_TAPCELL_ROW_54_452 VDD VSS gf180mcu_fd_sc_mcu7t5v0__filltie
XFILLER_39_207 VDD VDD VSS VSS gf180mcu_fd_sc_mcu7t5v0__fill_2
XFILLER_22_107 VDD VDD VSS VSS gf180mcu_fd_sc_mcu7t5v0__fill_1
XFILLER_22_129 VDD VDD VSS VSS gf180mcu_fd_sc_mcu7t5v0__fillcap_16
XFILLER_35_402 VDD VDD VSS VSS gf180mcu_fd_sc_mcu7t5v0__fillcap_16
XFILLER_50_427 VDD VDD VSS VSS gf180mcu_fd_sc_mcu7t5v0__fill_2
Xu_core.delay_paths.u_trc1.gen_inv_stage\[42\].inv u_core.delay_paths.u_trc1.gen_inv_stage\[42\].inv/I
+ u_core.delay_paths.u_trc1.gen_inv_stage\[43\].inv/I VDD VDD VSS VSS gf180mcu_fd_sc_mcu7t5v0__inv_1
XFILLER_30_140 VDD VDD VSS VSS gf180mcu_fd_sc_mcu7t5v0__fill_1
XFILLER_7_72 VDD VDD VSS VSS gf180mcu_fd_sc_mcu7t5v0__fillcap_32
Xu_core.delay_paths.u_trc1.gen_inv_stage\[57\].inv u_core.delay_paths.u_trc1.gen_inv_stage\[57\].inv/I
+ u_core.delay_paths.u_trc1.gen_inv_stage\[58\].inv/I VDD VDD VSS VSS gf180mcu_fd_sc_mcu7t5v0__inv_1
Xu_core.delay_paths.u_trc3.gen_inv_stage\[9\].inv u_core.delay_paths.u_trc3.gen_inv_stage\[9\].inv/I
+ u_core.delay_paths.u_trc3.gen_inv_stage\[9\].inv/ZN VDD VDD VSS VSS gf180mcu_fd_sc_mcu7t5v0__inv_1
XTAP_TAPCELL_ROW_60_499 VDD VSS gf180mcu_fd_sc_mcu7t5v0__filltie
XTAP_TAPCELL_ROW_60_488 VDD VSS gf180mcu_fd_sc_mcu7t5v0__filltie
XFILLER_26_37 VDD VDD VSS VSS gf180mcu_fd_sc_mcu7t5v0__fillcap_32
XFILLER_26_413 VDD VDD VSS VSS gf180mcu_fd_sc_mcu7t5v0__fill_2
XFILLER_13_107 VDD VDD VSS VSS gf180mcu_fd_sc_mcu7t5v0__fillcap_4
XFILLER_41_416 VDD VDD VSS VSS gf180mcu_fd_sc_mcu7t5v0__fillcap_4
XFILLER_53_276 VDD VDD VSS VSS gf180mcu_fd_sc_mcu7t5v0__fillcap_4
XTAP_TAPCELL_ROW_8_177 VDD VSS gf180mcu_fd_sc_mcu7t5v0__filltie
XFILLER_32_427 VDD VDD VSS VSS gf180mcu_fd_sc_mcu7t5v0__fill_2
X_623_ _623_/D _623_/RN _626_/CLK _623_/Q VDD VDD VSS VSS gf180mcu_fd_sc_mcu7t5v0__dffrnq_1
X_554_ _701_/Q _697_/Q _565_/A2 _554_/B2 _555_/I VDD VDD VSS VSS gf180mcu_fd_sc_mcu7t5v0__oai22_1
X_485_ _485_/I _667_/D VDD VDD VSS VSS gf180mcu_fd_sc_mcu7t5v0__clkinv_1
XFILLER_8_177 VDD VDD VSS VSS gf180mcu_fd_sc_mcu7t5v0__fillcap_16
XFILLER_23_405 VDD VDD VSS VSS gf180mcu_fd_sc_mcu7t5v0__fillcap_4
XFILLER_35_276 VDD VDD VSS VSS gf180mcu_fd_sc_mcu7t5v0__fillcap_4
Xu_core.delay_paths.u_trc0.gen_inv_stage\[130\].inv u_core.delay_paths.u_trc0.gen_inv_stage\[130\].inv/I
+ u_core.delay_paths.u_trc0.gen_inv_stage\[131\].inv/I VDD VDD VSS VSS gf180mcu_fd_sc_mcu7t5v0__inv_1
Xu_core.delay_paths.u_trc0.gen_inv_stage\[145\].inv u_core.delay_paths.u_trc0.gen_inv_stage\[145\].inv/I
+ u_core.delay_paths.u_trc0.gen_inv_stage\[146\].inv/I VDD VDD VSS VSS gf180mcu_fd_sc_mcu7t5v0__inv_1
XTAP_TAPCELL_ROW_5_158 VDD VSS gf180mcu_fd_sc_mcu7t5v0__filltie
XFILLER_41_202 VDD VDD VSS VSS gf180mcu_fd_sc_mcu7t5v0__fillcap_8
XFILLER_41_224 VDD VDD VSS VSS gf180mcu_fd_sc_mcu7t5v0__fill_1
XFILLER_41_235 VDD VDD VSS VSS gf180mcu_fd_sc_mcu7t5v0__fill_2
XFILLER_1_342 VDD VDD VSS VSS gf180mcu_fd_sc_mcu7t5v0__fillcap_4
Xu_core.delay_paths.u_trc0.gen_inv_stage\[81\].inv u_core.delay_paths.u_trc0.gen_inv_stage\[81\].inv/I
+ u_core.delay_paths.u_trc0.gen_inv_stage\[82\].inv/I VDD VDD VSS VSS gf180mcu_fd_sc_mcu7t5v0__inv_2
Xclkbuf_4_1__f_iCLK clkbuf_0_iCLK/Z _669_/CLK VDD VDD VSS VSS gf180mcu_fd_sc_mcu7t5v0__clkbuf_16
XFILLER_49_346 VDD VDD VSS VSS gf180mcu_fd_sc_mcu7t5v0__fillcap_4
Xu_core.delay_paths.u_trc0.gen_inv_stage\[96\].inv u_core.delay_paths.u_trc0.gen_inv_stage\[96\].inv/I
+ u_core.delay_paths.u_trc0.gen_inv_stage\[97\].inv/I VDD VDD VSS VSS gf180mcu_fd_sc_mcu7t5v0__inv_1
XFILLER_17_298 VDD VDD VSS VSS gf180mcu_fd_sc_mcu7t5v0__fillcap_4
X_606_ _606_/D wire28/I _644_/CLK _720_/I VDD VDD VSS VSS gf180mcu_fd_sc_mcu7t5v0__dffrnq_1
X_537_ _641_/Q _646_/Q _540_/S _646_/D VDD VDD VSS VSS gf180mcu_fd_sc_mcu7t5v0__mux2_2
X_468_ _700_/Q _492_/A1 _483_/A1 VDD VDD VSS VSS gf180mcu_fd_sc_mcu7t5v0__nand2_1
XTAP_TAPCELL_ROW_27_293 VDD VSS gf180mcu_fd_sc_mcu7t5v0__filltie
Xu_core.delay_paths.u_trc0.gen_inv_stage\[34\].inv u_core.delay_paths.u_trc0.gen_inv_stage\[34\].inv/I
+ u_core.delay_paths.u_trc0.gen_inv_stage\[35\].inv/I VDD VDD VSS VSS gf180mcu_fd_sc_mcu7t5v0__inv_1
X_399_ _685_/Q _394_/Z _399_/B _416_/B1 VDD VDD VSS VSS gf180mcu_fd_sc_mcu7t5v0__aoi21_1
XTAP_TAPCELL_ROW_10_193 VDD VSS gf180mcu_fd_sc_mcu7t5v0__filltie
XFILLER_4_73 VDD VDD VSS VSS gf180mcu_fd_sc_mcu7t5v0__fill_2
Xu_core.delay_paths.u_trc0.gen_inv_stage\[49\].inv u_core.delay_paths.u_trc0.gen_inv_stage\[49\].inv/I
+ u_core.delay_paths.u_trc0.gen_inv_stage\[50\].inv/I VDD VDD VSS VSS gf180mcu_fd_sc_mcu7t5v0__inv_1
XFILLER_11_419 VDD VDD VSS VSS gf180mcu_fd_sc_mcu7t5v0__fill_1
XFILLER_23_224 VDD VDD VSS VSS gf180mcu_fd_sc_mcu7t5v0__fill_2
XFILLER_31_290 VDD VDD VSS VSS gf180mcu_fd_sc_mcu7t5v0__fill_1
XFILLER_14_257 VDD VDD VSS VSS gf180mcu_fd_sc_mcu7t5v0__fillcap_16
X_322_ _627_/Q _443_/A1 VDD VDD VSS VSS gf180mcu_fd_sc_mcu7t5v0__clkinv_1
XTAP_TAPCELL_ROW_24_274 VDD VSS gf180mcu_fd_sc_mcu7t5v0__filltie
XFILLER_1_194 VDD VDD VSS VSS gf180mcu_fd_sc_mcu7t5v0__fillcap_16
XFILLER_37_316 VDD VDD VSS VSS gf180mcu_fd_sc_mcu7t5v0__fill_2
XFILLER_37_327 VDD VDD VSS VSS gf180mcu_fd_sc_mcu7t5v0__fillcap_16
XFILLER_37_349 VDD VDD VSS VSS gf180mcu_fd_sc_mcu7t5v0__fill_1
XFILLER_11_205 VDD VDD VSS VSS gf180mcu_fd_sc_mcu7t5v0__fillcap_4
XFILLER_34_37 VDD VDD VSS VSS gf180mcu_fd_sc_mcu7t5v0__fillcap_8
XFILLER_51_352 VDD VDD VSS VSS gf180mcu_fd_sc_mcu7t5v0__fillcap_64
Xclkload3 _665_/CLK clkload3/Z VDD VDD VSS VSS gf180mcu_fd_sc_mcu7t5v0__clkbuf_2
XTAP_TAPCELL_ROW_21_255 VDD VSS gf180mcu_fd_sc_mcu7t5v0__filltie
X_305_ _623_/Q _623_/D VDD VDD VSS VSS gf180mcu_fd_sc_mcu7t5v0__clkinv_1
XTAP_TAPCELL_ROW_12_200 VDD VSS gf180mcu_fd_sc_mcu7t5v0__filltie
Xu_core.delay_paths.u_trc3.gen_inv_stage\[10\].inv u_core.delay_paths.u_trc3.gen_inv_stage\[9\].inv/ZN
+ u_core.delay_paths.u_trc3.gen_inv_stage\[11\].inv/I VDD VDD VSS VSS gf180mcu_fd_sc_mcu7t5v0__inv_1
XFILLER_18_382 VDD VDD VSS VSS gf180mcu_fd_sc_mcu7t5v0__fill_2
XFILLER_37_168 VDD VDD VSS VSS gf180mcu_fd_sc_mcu7t5v0__fill_1
Xu_core.delay_paths.u_trc3.gen_inv_stage\[25\].inv u_core.delay_paths.u_trc3.gen_inv_stage\[25\].inv/I
+ u_core.delay_paths.u_trc3.gen_inv_stage\[26\].inv/I VDD VDD VSS VSS gf180mcu_fd_sc_mcu7t5v0__inv_1
XFILLER_60_160 VDD VDD VSS VSS gf180mcu_fd_sc_mcu7t5v0__fill_1
XTAP_TAPCELL_ROW_43_391 VDD VSS gf180mcu_fd_sc_mcu7t5v0__filltie
XFILLER_0_407 VDD VDD VSS VSS gf180mcu_fd_sc_mcu7t5v0__fill_1
XFILLER_28_146 VDD VDD VSS VSS gf180mcu_fd_sc_mcu7t5v0__fillcap_8
XFILLER_28_168 VDD VDD VSS VSS gf180mcu_fd_sc_mcu7t5v0__fillcap_4
Xhold59 _705_/Q _691_/D VDD VDD VSS VSS gf180mcu_fd_sc_mcu7t5v0__dlyc_1
XFILLER_45_69 VDD VDD VSS VSS gf180mcu_fd_sc_mcu7t5v0__fill_1
XFILLER_3_212 VDD VDD VSS VSS gf180mcu_fd_sc_mcu7t5v0__fillcap_16
XFILLER_19_102 VDD VDD VSS VSS gf180mcu_fd_sc_mcu7t5v0__fill_1
XFILLER_3_278 VDD VDD VSS VSS gf180mcu_fd_sc_mcu7t5v0__fill_2
XFILLER_3_289 VDD VDD VSS VSS gf180mcu_fd_sc_mcu7t5v0__fill_1
XFILLER_47_422 VDD VDD VSS VSS gf180mcu_fd_sc_mcu7t5v0__fillcap_8
XFILLER_59_282 VDD VDD VSS VSS gf180mcu_fd_sc_mcu7t5v0__fillcap_64
XFILLER_27_190 VDD VDD VSS VSS gf180mcu_fd_sc_mcu7t5v0__fillcap_4
XTAP_TAPCELL_ROW_57_472 VDD VSS gf180mcu_fd_sc_mcu7t5v0__filltie
XFILLER_30_344 VDD VDD VSS VSS gf180mcu_fd_sc_mcu7t5v0__fill_1
XFILLER_35_80 VDD VDD VSS VSS gf180mcu_fd_sc_mcu7t5v0__fillcap_4
XFILLER_42_193 VDD VDD VSS VSS gf180mcu_fd_sc_mcu7t5v0__fillcap_4
XTAP_TAPCELL_ROW_40_372 VDD VSS gf180mcu_fd_sc_mcu7t5v0__filltie
XFILLER_32_2 VDD VDD VSS VSS gf180mcu_fd_sc_mcu7t5v0__fillcap_32
XFILLER_21_333 VDD VDD VSS VSS gf180mcu_fd_sc_mcu7t5v0__fillcap_4
XFILLER_25_116 VDD VDD VSS VSS gf180mcu_fd_sc_mcu7t5v0__fillcap_8
XFILLER_33_171 VDD VDD VSS VSS gf180mcu_fd_sc_mcu7t5v0__fillcap_4
XFILLER_29_422 VDD VDD VSS VSS gf180mcu_fd_sc_mcu7t5v0__fillcap_8
XFILLER_56_241 VDD VDD VSS VSS gf180mcu_fd_sc_mcu7t5v0__fillcap_4
X_570_ _570_/A1 _556_/Z _570_/B _572_/B VDD VDD VSS VSS gf180mcu_fd_sc_mcu7t5v0__aoi21_1
XTAP_TAPCELL_ROW_54_453 VDD VSS gf180mcu_fd_sc_mcu7t5v0__filltie
XTAP_TAPCELL_ROW_46_409 VDD VSS gf180mcu_fd_sc_mcu7t5v0__filltie
Xu_core.delay_paths.u_trc2.gen_inv_stage\[64\].inv u_core.delay_paths.u_trc2.gen_inv_stage\[64\].inv/I
+ u_core.delay_paths.u_trc2.gen_inv_stage\[65\].inv/I VDD VDD VSS VSS gf180mcu_fd_sc_mcu7t5v0__inv_1
Xu_core.delay_paths.u_trc2.gen_inv_stage\[79\].inv u_core.delay_paths.u_trc2.gen_inv_stage\[79\].inv/I
+ u_core.delay_paths.u_trc2.gen_inv_stage\[80\].inv/I VDD VDD VSS VSS gf180mcu_fd_sc_mcu7t5v0__inv_1
XFILLER_15_171 VDD VDD VSS VSS gf180mcu_fd_sc_mcu7t5v0__fill_2
X_699_ _699_/D _699_/RN _699_/CLK _699_/Q VDD VDD VSS VSS gf180mcu_fd_sc_mcu7t5v0__dffrnq_1
Xu_core.delay_paths.u_trc2.gen_inv_stage\[17\].inv u_core.delay_paths.u_trc2.gen_inv_stage\[17\].inv/I
+ u_core.delay_paths.u_trc2.gen_inv_stage\[18\].inv/I VDD VDD VSS VSS gf180mcu_fd_sc_mcu7t5v0__inv_1
XTAP_TAPCELL_ROW_60_489 VDD VSS gf180mcu_fd_sc_mcu7t5v0__filltie
XPHY_EDGE_ROW_15_Right_15 VDD VSS gf180mcu_fd_sc_mcu7t5v0__endcap
XFILLER_38_263 VDD VDD VSS VSS gf180mcu_fd_sc_mcu7t5v0__fill_2
XPHY_EDGE_ROW_24_Right_24 VDD VSS gf180mcu_fd_sc_mcu7t5v0__endcap
XTAP_TAPCELL_ROW_51_434 VDD VSS gf180mcu_fd_sc_mcu7t5v0__filltie
XPHY_EDGE_ROW_33_Right_33 VDD VSS gf180mcu_fd_sc_mcu7t5v0__endcap
X_622_ _622_/D _687_/RN _644_/CLK _622_/Q VDD VDD VSS VSS gf180mcu_fd_sc_mcu7t5v0__dffrnq_1
XTAP_TAPCELL_ROW_8_178 VDD VSS gf180mcu_fd_sc_mcu7t5v0__filltie
XFILLER_17_414 VDD VDD VSS VSS gf180mcu_fd_sc_mcu7t5v0__fillcap_4
XFILLER_44_244 VDD VDD VSS VSS gf180mcu_fd_sc_mcu7t5v0__fill_1
Xu_core.delay_paths.u_trc1.gen_inv_stage\[104\].inv u_core.delay_paths.u_trc1.gen_inv_stage\[104\].inv/I
+ u_core.delay_paths.u_trc1.gen_inv_stage\[105\].inv/I VDD VDD VSS VSS gf180mcu_fd_sc_mcu7t5v0__inv_1
X_553_ _657_/Q _656_/Q _697_/Q _554_/B2 VDD VDD VSS VSS gf180mcu_fd_sc_mcu7t5v0__nand3_1
X_484_ _667_/Q _489_/A3 _484_/B _485_/I VDD VDD VSS VSS gf180mcu_fd_sc_mcu7t5v0__oai21_1
XPHY_EDGE_ROW_42_Right_42 VDD VSS gf180mcu_fd_sc_mcu7t5v0__endcap
XFILLER_12_130 VDD VDD VSS VSS gf180mcu_fd_sc_mcu7t5v0__fill_1
XFILLER_8_101 VDD VDD VSS VSS gf180mcu_fd_sc_mcu7t5v0__fillcap_4
Xu_core.delay_paths.u_trc1.gen_inv_stage\[119\].inv u_core.delay_paths.u_trc1.gen_inv_stage\[119\].inv/I
+ u_core.delay_paths.u_trc1.gen_inv_stage\[120\].inv/I VDD VDD VSS VSS gf180mcu_fd_sc_mcu7t5v0__inv_1
XPHY_EDGE_ROW_51_Right_51 VDD VSS gf180mcu_fd_sc_mcu7t5v0__endcap
XFILLER_4_373 VDD VDD VSS VSS gf180mcu_fd_sc_mcu7t5v0__fillcap_4
XFILLER_4_384 VDD VDD VSS VSS gf180mcu_fd_sc_mcu7t5v0__fill_1
XPHY_EDGE_ROW_60_Right_60 VDD VSS gf180mcu_fd_sc_mcu7t5v0__endcap
XFILLER_50_247 VDD VDD VSS VSS gf180mcu_fd_sc_mcu7t5v0__fillcap_64
XTAP_TAPCELL_ROW_5_159 VDD VSS gf180mcu_fd_sc_mcu7t5v0__filltie
XFILLER_26_233 VDD VDD VSS VSS gf180mcu_fd_sc_mcu7t5v0__fillcap_4
Xu_core.delay_paths.u_trc1.gen_inv_stage\[9\].inv u_core.delay_paths.u_trc1.gen_inv_stage\[9\].inv/I
+ u_core.delay_paths.u_trc1.gen_inv_stage\[9\].inv/ZN VDD VDD VSS VSS gf180mcu_fd_sc_mcu7t5v0__inv_1
XFILLER_5_126 VDD VDD VSS VSS gf180mcu_fd_sc_mcu7t5v0__fillcap_8
XFILLER_1_365 VDD VDD VSS VSS gf180mcu_fd_sc_mcu7t5v0__fill_2
Xu_core.delay_paths.u_trc1.gen_inv_stage\[41\].inv u_core.delay_paths.u_trc1.gen_inv_stage\[41\].inv/I
+ u_core.delay_paths.u_trc1.gen_inv_stage\[42\].inv/I VDD VDD VSS VSS gf180mcu_fd_sc_mcu7t5v0__inv_1
XFILLER_17_233 VDD VDD VSS VSS gf180mcu_fd_sc_mcu7t5v0__fillcap_8
Xu_core.delay_paths.u_trc1.gen_inv_stage\[56\].inv u_core.delay_paths.u_trc1.gen_inv_stage\[56\].inv/I
+ u_core.delay_paths.u_trc1.gen_inv_stage\[57\].inv/I VDD VDD VSS VSS gf180mcu_fd_sc_mcu7t5v0__inv_1
Xu_core.delay_paths.u_trc3.gen_inv_stage\[8\].inv u_core.delay_paths.u_trc3.gen_inv_stage\[8\].inv/I
+ u_core.delay_paths.u_trc3.gen_inv_stage\[9\].inv/I VDD VDD VSS VSS gf180mcu_fd_sc_mcu7t5v0__inv_1
X_605_ _605_/D _687_/RN _644_/CLK _605_/Q VDD VDD VSS VSS gf180mcu_fd_sc_mcu7t5v0__dffrnq_1
XFILLER_32_247 VDD VDD VSS VSS gf180mcu_fd_sc_mcu7t5v0__fillcap_4
X_536_ _640_/Q _645_/Q _540_/S _645_/D VDD VDD VSS VSS gf180mcu_fd_sc_mcu7t5v0__mux2_2
X_467_ _700_/Q _466_/Z _481_/B VDD VDD VSS VSS gf180mcu_fd_sc_mcu7t5v0__nor2_1
X_398_ _416_/A1 _396_/Z _422_/A2 VDD VDD VSS VSS gf180mcu_fd_sc_mcu7t5v0__nand2_1
XTAP_TAPCELL_ROW_27_294 VDD VSS gf180mcu_fd_sc_mcu7t5v0__filltie
XFILLER_4_30 VDD VDD VSS VSS gf180mcu_fd_sc_mcu7t5v0__fillcap_4
XFILLER_4_85 VDD VDD VSS VSS gf180mcu_fd_sc_mcu7t5v0__fill_1
XFILLER_4_96 VDD VDD VSS VSS gf180mcu_fd_sc_mcu7t5v0__fill_1
XFILLER_2_107 VDD VDD VSS VSS gf180mcu_fd_sc_mcu7t5v0__fillcap_4
XFILLER_46_317 VDD VDD VSS VSS gf180mcu_fd_sc_mcu7t5v0__fillcap_64
XFILLER_58_177 VDD VDD VSS VSS gf180mcu_fd_sc_mcu7t5v0__fillcap_64
XFILLER_14_247 VDD VDD VSS VSS gf180mcu_fd_sc_mcu7t5v0__fill_2
Xfanout40 _693_/RN _691_/RN VDD VDD VSS VSS gf180mcu_fd_sc_mcu7t5v0__dlyb_1
X_321_ _636_/Q _525_/A1 VDD VDD VSS VSS gf180mcu_fd_sc_mcu7t5v0__clkinv_1
XTAP_TAPCELL_ROW_24_275 VDD VSS gf180mcu_fd_sc_mcu7t5v0__filltie
XFILLER_13_72 VDD VDD VSS VSS gf180mcu_fd_sc_mcu7t5v0__fillcap_4
Xu_core.delay_paths.u_trc0.gen_inv_stage\[191\].inv u_core.delay_paths.u_trc0.gen_inv_stage\[191\].inv/I
+ _719_/I VDD VDD VSS VSS gf180mcu_fd_sc_mcu7t5v0__clkinv_2
XFILLER_60_342 VDD VDD VSS VSS gf180mcu_fd_sc_mcu7t5v0__fillcap_32
Xu_core.delay_paths.u_trc0.gen_inv_stage\[144\].inv u_core.delay_paths.u_trc0.gen_inv_stage\[144\].inv/I
+ u_core.delay_paths.u_trc0.gen_inv_stage\[145\].inv/I VDD VDD VSS VSS gf180mcu_fd_sc_mcu7t5v0__inv_1
Xclkload10 _695_/CLK clkload10/Z VDD VDD VSS VSS gf180mcu_fd_sc_mcu7t5v0__clkbuf_2
X_519_ _519_/A1 _517_/S _519_/B _695_/D VDD VDD VSS VSS gf180mcu_fd_sc_mcu7t5v0__aoi21_1
XTAP_TAPCELL_ROW_15_220 VDD VSS gf180mcu_fd_sc_mcu7t5v0__filltie
XPHY_EDGE_ROW_41_Left_102 VDD VSS gf180mcu_fd_sc_mcu7t5v0__endcap
Xu_core.delay_paths.u_trc0.gen_inv_stage\[159\].inv u_core.delay_paths.u_trc0.gen_inv_stage\[159\].inv/I
+ u_core.delay_paths.u_trc0.gen_inv_stage\[160\].inv/I VDD VDD VSS VSS gf180mcu_fd_sc_mcu7t5v0__inv_1
XFILLER_28_306 VDD VDD VSS VSS gf180mcu_fd_sc_mcu7t5v0__fillcap_8
XFILLER_28_317 VDD VDD VSS VSS gf180mcu_fd_sc_mcu7t5v0__fillcap_8
XFILLER_55_136 VDD VDD VSS VSS gf180mcu_fd_sc_mcu7t5v0__fillcap_4
XPHY_EDGE_ROW_50_Left_111 VDD VSS gf180mcu_fd_sc_mcu7t5v0__endcap
Xu_core.delay_paths.u_trc0.gen_inv_stage\[80\].inv u_core.delay_paths.u_trc0.gen_inv_stage\[80\].inv/I
+ u_core.delay_paths.u_trc0.gen_inv_stage\[81\].inv/I VDD VDD VSS VSS gf180mcu_fd_sc_mcu7t5v0__inv_2
XTAP_TAPCELL_ROW_38_356 VDD VSS gf180mcu_fd_sc_mcu7t5v0__filltie
XFILLER_50_37 VDD VDD VSS VSS gf180mcu_fd_sc_mcu7t5v0__fillcap_64
Xu_core.delay_paths.u_trc0.gen_inv_stage\[95\].inv u_core.delay_paths.u_trc0.gen_inv_stage\[95\].inv/I
+ u_core.delay_paths.u_trc0.gen_inv_stage\[96\].inv/I VDD VDD VSS VSS gf180mcu_fd_sc_mcu7t5v0__inv_1
Xclkload4 _682_/CLK clkload4/Z VDD VDD VSS VSS gf180mcu_fd_sc_mcu7t5v0__clkbuf_2
XTAP_TAPCELL_ROW_21_256 VDD VSS gf180mcu_fd_sc_mcu7t5v0__filltie
Xu_core.delay_paths.u_trc0.gen_inv_stage\[33\].inv u_core.delay_paths.u_trc0.gen_inv_stage\[33\].inv/I
+ u_core.delay_paths.u_trc0.gen_inv_stage\[34\].inv/I VDD VDD VSS VSS gf180mcu_fd_sc_mcu7t5v0__inv_1
XFILLER_24_93 VDD VDD VSS VSS gf180mcu_fd_sc_mcu7t5v0__fill_2
Xu_core.delay_paths.u_trc0.gen_inv_stage\[48\].inv u_core.delay_paths.u_trc0.gen_inv_stage\[48\].inv/I
+ u_core.delay_paths.u_trc0.gen_inv_stage\[49\].inv/I VDD VDD VSS VSS gf180mcu_fd_sc_mcu7t5v0__inv_1
X_304_ _724_/I _610_/D VDD VDD VSS VSS gf180mcu_fd_sc_mcu7t5v0__clkinv_1
XTAP_TAPCELL_ROW_12_201 VDD VSS gf180mcu_fd_sc_mcu7t5v0__filltie
XFILLER_6_265 VDD VDD VSS VSS gf180mcu_fd_sc_mcu7t5v0__fill_1
XFILLER_60_172 VDD VDD VSS VSS gf180mcu_fd_sc_mcu7t5v0__fillcap_32
XFILLER_28_103 VDD VDD VSS VSS gf180mcu_fd_sc_mcu7t5v0__fill_2
XFILLER_43_139 VDD VDD VSS VSS gf180mcu_fd_sc_mcu7t5v0__fill_1
XPHY_EDGE_ROW_7_Left_68 VDD VSS gf180mcu_fd_sc_mcu7t5v0__endcap
XFILLER_19_114 VDD VDD VSS VSS gf180mcu_fd_sc_mcu7t5v0__fill_1
XFILLER_19_125 VDD VDD VSS VSS gf180mcu_fd_sc_mcu7t5v0__fill_1
XTAP_TAPCELL_ROW_57_473 VDD VSS gf180mcu_fd_sc_mcu7t5v0__filltie
XTAP_TAPCELL_ROW_40_373 VDD VSS gf180mcu_fd_sc_mcu7t5v0__filltie
XFILLER_25_139 VDD VDD VSS VSS gf180mcu_fd_sc_mcu7t5v0__fill_1
XFILLER_25_2 VDD VDD VSS VSS gf180mcu_fd_sc_mcu7t5v0__fillcap_64
XFILLER_29_412 VDD VDD VSS VSS gf180mcu_fd_sc_mcu7t5v0__fillcap_8
XTAP_TAPCELL_ROW_54_454 VDD VSS gf180mcu_fd_sc_mcu7t5v0__filltie
XFILLER_8_305 VDD VDD VSS VSS gf180mcu_fd_sc_mcu7t5v0__fill_1
XFILLER_21_72 VDD VDD VSS VSS gf180mcu_fd_sc_mcu7t5v0__fillcap_16
Xu_core.delay_paths.u_trc3.gen_inv_stage\[24\].inv u_core.delay_paths.u_trc3.gen_inv_stage\[24\].inv/I
+ u_core.delay_paths.u_trc3.gen_inv_stage\[25\].inv/I VDD VDD VSS VSS gf180mcu_fd_sc_mcu7t5v0__inv_1
XFILLER_39_209 VDD VDD VSS VSS gf180mcu_fd_sc_mcu7t5v0__fill_1
Xu_core.delay_paths.u_trc3.gen_inv_stage\[39\].inv u_core.delay_paths.u_trc3.gen_inv_stage\[39\].inv/I
+ u_core.delay_paths.u_trc3.gen_inv_stage\[40\].inv/I VDD VDD VSS VSS gf180mcu_fd_sc_mcu7t5v0__inv_1
XFILLER_50_429 VDD VDD VSS VSS gf180mcu_fd_sc_mcu7t5v0__fill_1
Xmax_cap70 _515_/S _504_/S VDD VDD VSS VSS gf180mcu_fd_sc_mcu7t5v0__buf_4
X_698_ _698_/D _700_/RN _705_/CLK _698_/Q VDD VDD VSS VSS gf180mcu_fd_sc_mcu7t5v0__dffrnq_1
XFILLER_7_360 VDD VDD VSS VSS gf180mcu_fd_sc_mcu7t5v0__fill_1
XFILLER_26_415 VDD VDD VSS VSS gf180mcu_fd_sc_mcu7t5v0__fill_1
XFILLER_38_275 VDD VDD VSS VSS gf180mcu_fd_sc_mcu7t5v0__fillcap_4
XFILLER_53_212 VDD VDD VSS VSS gf180mcu_fd_sc_mcu7t5v0__fillcap_64
XFILLER_21_131 VDD VDD VSS VSS gf180mcu_fd_sc_mcu7t5v0__fillcap_4
XTAP_TAPCELL_ROW_51_435 VDD VSS gf180mcu_fd_sc_mcu7t5v0__filltie
XFILLER_17_426 VDD VDD VSS VSS gf180mcu_fd_sc_mcu7t5v0__fillcap_4
XFILLER_29_297 VDD VDD VSS VSS gf180mcu_fd_sc_mcu7t5v0__fill_1
X_621_ _621_/D _695_/RN _694_/CLK _621_/Q VDD VDD VSS VSS gf180mcu_fd_sc_mcu7t5v0__dffrnq_1
XTAP_TAPCELL_ROW_8_179 VDD VSS gf180mcu_fd_sc_mcu7t5v0__filltie
XFILLER_12_153 VDD VDD VSS VSS gf180mcu_fd_sc_mcu7t5v0__fillcap_16
XFILLER_32_429 VDD VDD VSS VSS gf180mcu_fd_sc_mcu7t5v0__fill_1
X_552_ _658_/Q _659_/Q _661_/Q _660_/Q _565_/A2 VDD VDD VSS VSS gf180mcu_fd_sc_mcu7t5v0__nand4_1
X_483_ _483_/A1 _483_/A2 _489_/A3 VDD VDD VSS VSS gf180mcu_fd_sc_mcu7t5v0__nor2_1
XFILLER_12_186 VDD VDD VSS VSS gf180mcu_fd_sc_mcu7t5v0__fillcap_8
XFILLER_35_212 VDD VDD VSS VSS gf180mcu_fd_sc_mcu7t5v0__fillcap_8
XFILLER_7_190 VDD VDD VSS VSS gf180mcu_fd_sc_mcu7t5v0__fillcap_4
XFILLER_14_429 VDD VDD VSS VSS gf180mcu_fd_sc_mcu7t5v0__fill_1
Xu_core.delay_paths.u_trc2.gen_inv_stage\[63\].inv u_core.delay_paths.u_trc2.gen_inv_stage\[63\].inv/I
+ u_core.delay_paths.u_trc2.gen_inv_stage\[64\].inv/I VDD VDD VSS VSS gf180mcu_fd_sc_mcu7t5v0__inv_1
XFILLER_5_116 VDD VDD VSS VSS gf180mcu_fd_sc_mcu7t5v0__fill_2
XFILLER_5_138 VDD VDD VSS VSS gf180mcu_fd_sc_mcu7t5v0__fill_2
Xu_core.delay_paths.u_trc2.gen_inv_stage\[78\].inv u_core.delay_paths.u_trc2.gen_inv_stage\[78\].inv/I
+ u_core.delay_paths.u_trc2.gen_inv_stage\[79\].inv/I VDD VDD VSS VSS gf180mcu_fd_sc_mcu7t5v0__inv_1
Xu_core.delay_paths.u_trc2.gen_inv_stage\[16\].inv u_core.delay_paths.u_trc2.gen_inv_stage\[16\].inv/I
+ u_core.delay_paths.u_trc2.gen_inv_stage\[17\].inv/I VDD VDD VSS VSS gf180mcu_fd_sc_mcu7t5v0__inv_1
XPHY_EDGE_ROW_36_Left_97 VDD VSS gf180mcu_fd_sc_mcu7t5v0__endcap
XFILLER_17_212 VDD VDD VSS VSS gf180mcu_fd_sc_mcu7t5v0__fill_2
XFILLER_17_245 VDD VDD VSS VSS gf180mcu_fd_sc_mcu7t5v0__fill_1
XFILLER_27_82 VDD VDD VSS VSS gf180mcu_fd_sc_mcu7t5v0__fillcap_8
XFILLER_32_204 VDD VDD VSS VSS gf180mcu_fd_sc_mcu7t5v0__fillcap_4
X_604_ _604_/D wire28/Z _665_/CLK _718_/I VDD VDD VSS VSS gf180mcu_fd_sc_mcu7t5v0__dffrnq_2
X_535_ _622_/Q _535_/A2 _539_/S VDD VDD VSS VSS gf180mcu_fd_sc_mcu7t5v0__nand2_1
X_466_ _696_/D _696_/Q _466_/Z VDD VDD VSS VSS gf180mcu_fd_sc_mcu7t5v0__or2_1
X_397_ _684_/Q _397_/A2 _397_/B _397_/C _420_/A2 VDD VDD VSS VSS gf180mcu_fd_sc_mcu7t5v0__aoi211_1
XTAP_TAPCELL_ROW_27_295 VDD VSS gf180mcu_fd_sc_mcu7t5v0__filltie
XFILLER_4_193 VDD VDD VSS VSS gf180mcu_fd_sc_mcu7t5v0__fill_2
XFILLER_4_75 VDD VDD VSS VSS gf180mcu_fd_sc_mcu7t5v0__fill_1
XFILLER_48_381 VDD VDD VSS VSS gf180mcu_fd_sc_mcu7t5v0__fillcap_4
XTAP_TAPCELL_ROW_18_240 VDD VSS gf180mcu_fd_sc_mcu7t5v0__filltie
XFILLER_48_37 VDD VDD VSS VSS gf180mcu_fd_sc_mcu7t5v0__fillcap_16
XFILLER_58_101 VDD VDD VSS VSS gf180mcu_fd_sc_mcu7t5v0__fillcap_4
Xu_core.delay_paths.u_trc1.gen_inv_stage\[103\].inv u_core.delay_paths.u_trc1.gen_inv_stage\[103\].inv/I
+ u_core.delay_paths.u_trc1.gen_inv_stage\[104\].inv/I VDD VDD VSS VSS gf180mcu_fd_sc_mcu7t5v0__inv_1
Xu_core.delay_paths.u_trc1.gen_inv_stage\[118\].inv u_core.delay_paths.u_trc1.gen_inv_stage\[118\].inv/I
+ u_core.delay_paths.u_trc1.gen_inv_stage\[119\].inv/I VDD VDD VSS VSS gf180mcu_fd_sc_mcu7t5v0__inv_1
Xfanout41 _693_/RN _705_/RN VDD VDD VSS VSS gf180mcu_fd_sc_mcu7t5v0__dlyb_1
X_320_ _695_/Q _519_/A1 VDD VDD VSS VSS gf180mcu_fd_sc_mcu7t5v0__clkinv_1
XTAP_TAPCELL_ROW_24_276 VDD VSS gf180mcu_fd_sc_mcu7t5v0__filltie
XFILLER_1_185 VDD VDD VSS VSS gf180mcu_fd_sc_mcu7t5v0__fillcap_4
XFILLER_37_318 VDD VDD VSS VSS gf180mcu_fd_sc_mcu7t5v0__fill_1
XFILLER_49_134 VDD VDD VSS VSS gf180mcu_fd_sc_mcu7t5v0__fillcap_4
X_518_ _618_/D _517_/S _519_/B VDD VDD VSS VSS gf180mcu_fd_sc_mcu7t5v0__nor2_1
XTAP_TAPCELL_ROW_15_221 VDD VSS gf180mcu_fd_sc_mcu7t5v0__filltie
XFILLER_60_376 VDD VDD VSS VSS gf180mcu_fd_sc_mcu7t5v0__fillcap_32
Xclkload11 _694_/CLK clkload11/Z VDD VDD VSS VSS gf180mcu_fd_sc_mcu7t5v0__clkbuf_2
X_449_ _449_/A1 _453_/B _451_/B1 _449_/B2 _630_/D VDD VDD VSS VSS gf180mcu_fd_sc_mcu7t5v0__aoi22_1
XFILLER_9_230 VDD VDD VSS VSS gf180mcu_fd_sc_mcu7t5v0__fill_1
XFILLER_55_2 VDD VDD VSS VSS gf180mcu_fd_sc_mcu7t5v0__fillcap_64
Xu_core.delay_paths.u_trc1.gen_inv_stage\[8\].inv u_core.delay_paths.u_trc1.gen_inv_stage\[8\].inv/I
+ u_core.delay_paths.u_trc1.gen_inv_stage\[9\].inv/I VDD VDD VSS VSS gf180mcu_fd_sc_mcu7t5v0__inv_1
XTAP_TAPCELL_ROW_38_357 VDD VSS gf180mcu_fd_sc_mcu7t5v0__filltie
Xu_core.delay_paths.u_trc1.gen_inv_stage\[40\].inv u_core.delay_paths.u_trc1.gen_inv_stage\[40\].inv/I
+ u_core.delay_paths.u_trc1.gen_inv_stage\[41\].inv/I VDD VDD VSS VSS gf180mcu_fd_sc_mcu7t5v0__inv_1
Xclkload5 _685_/CLK clkload5/Z VDD VDD VSS VSS gf180mcu_fd_sc_mcu7t5v0__clkbuf_2
Xu_core.delay_paths.u_trc1.gen_inv_stage\[55\].inv u_core.delay_paths.u_trc1.gen_inv_stage\[55\].inv/I
+ u_core.delay_paths.u_trc1.gen_inv_stage\[56\].inv/I VDD VDD VSS VSS gf180mcu_fd_sc_mcu7t5v0__inv_1
Xu_core.delay_paths.u_trc3.gen_inv_stage\[7\].inv u_core.delay_paths.u_trc3.gen_inv_stage\[7\].inv/I
+ u_core.delay_paths.u_trc3.gen_inv_stage\[8\].inv/I VDD VDD VSS VSS gf180mcu_fd_sc_mcu7t5v0__inv_1
XTAP_TAPCELL_ROW_21_257 VDD VSS gf180mcu_fd_sc_mcu7t5v0__filltie
XTAP_TAPCELL_ROW_29_302 VDD VSS gf180mcu_fd_sc_mcu7t5v0__filltie
Xload_slew39 _619_/RN _695_/RN VDD VDD VSS VSS gf180mcu_fd_sc_mcu7t5v0__buf_4
XFILLER_42_387 VDD VDD VSS VSS gf180mcu_fd_sc_mcu7t5v0__fillcap_32
X_303_ _722_/I _608_/D VDD VDD VSS VSS gf180mcu_fd_sc_mcu7t5v0__clkinv_1
XTAP_TAPCELL_ROW_12_202 VDD VSS gf180mcu_fd_sc_mcu7t5v0__filltie
XFILLER_1_10 VDD VDD VSS VSS gf180mcu_fd_sc_mcu7t5v0__fillcap_32
XFILLER_37_137 VDD VDD VSS VSS gf180mcu_fd_sc_mcu7t5v0__fill_2
XFILLER_52_107 VDD VDD VSS VSS gf180mcu_fd_sc_mcu7t5v0__fillcap_64
XFILLER_18_384 VDD VDD VSS VSS gf180mcu_fd_sc_mcu7t5v0__fill_1
XFILLER_33_343 VDD VDD VSS VSS gf180mcu_fd_sc_mcu7t5v0__fillcap_4
XFILLER_33_376 VDD VDD VSS VSS gf180mcu_fd_sc_mcu7t5v0__fill_1
XTAP_TAPCELL_ROW_35_338 VDD VSS gf180mcu_fd_sc_mcu7t5v0__filltie
XPHY_EDGE_ROW_23_Left_84 VDD VSS gf180mcu_fd_sc_mcu7t5v0__endcap
XFILLER_28_115 VDD VDD VSS VSS gf180mcu_fd_sc_mcu7t5v0__fillcap_4
Xu_core.delay_paths.u_trc0.gen_inv_stage\[190\].inv u_core.delay_paths.u_trc0.gen_inv_stage\[190\].inv/I
+ u_core.delay_paths.u_trc0.gen_inv_stage\[191\].inv/I VDD VDD VSS VSS gf180mcu_fd_sc_mcu7t5v0__inv_1
XFILLER_24_365 VDD VDD VSS VSS gf180mcu_fd_sc_mcu7t5v0__fill_2
XFILLER_24_387 VDD VDD VSS VSS gf180mcu_fd_sc_mcu7t5v0__fillcap_4
XFILLER_3_236 VDD VDD VSS VSS gf180mcu_fd_sc_mcu7t5v0__fillcap_4
XFILLER_19_72 VDD VDD VSS VSS gf180mcu_fd_sc_mcu7t5v0__fillcap_16
Xu_core.delay_paths.u_trc0.gen_inv_stage\[143\].inv u_core.delay_paths.u_trc0.gen_inv_stage\[143\].inv/I
+ u_core.delay_paths.u_trc0.gen_inv_stage\[144\].inv/I VDD VDD VSS VSS gf180mcu_fd_sc_mcu7t5v0__inv_1
XFILLER_34_107 VDD VDD VSS VSS gf180mcu_fd_sc_mcu7t5v0__fillcap_16
XFILLER_34_129 VDD VDD VSS VSS gf180mcu_fd_sc_mcu7t5v0__fillcap_4
Xu_core.delay_paths.u_trc0.gen_inv_stage\[158\].inv u_core.delay_paths.u_trc0.gen_inv_stage\[158\].inv/I
+ u_core.delay_paths.u_trc0.gen_inv_stage\[159\].inv/I VDD VDD VSS VSS gf180mcu_fd_sc_mcu7t5v0__inv_1
XTAP_TAPCELL_ROW_57_474 VDD VSS gf180mcu_fd_sc_mcu7t5v0__filltie
XFILLER_18_2 VDD VDD VSS VSS gf180mcu_fd_sc_mcu7t5v0__fillcap_32
XFILLER_53_416 VDD VDD VSS VSS gf180mcu_fd_sc_mcu7t5v0__fillcap_4
Xu_core.delay_paths.u_trc0.gen_inv_stage\[94\].inv u_core.delay_paths.u_trc0.gen_inv_stage\[94\].inv/I
+ u_core.delay_paths.u_trc0.gen_inv_stage\[95\].inv/I VDD VDD VSS VSS gf180mcu_fd_sc_mcu7t5v0__inv_1
XFILLER_0_206 VDD VDD VSS VSS gf180mcu_fd_sc_mcu7t5v0__fillcap_32
Xu_core.delay_paths.u_trc0.gen_inv_stage\[32\].inv u_core.delay_paths.u_trc0.gen_inv_stage\[32\].inv/I
+ u_core.delay_paths.u_trc0.gen_inv_stage\[33\].inv/I VDD VDD VSS VSS gf180mcu_fd_sc_mcu7t5v0__inv_1
XFILLER_56_37 VDD VDD VSS VSS gf180mcu_fd_sc_mcu7t5v0__fillcap_64
Xu_core.delay_paths.u_trc0.gen_inv_stage\[47\].inv u_core.delay_paths.u_trc0.gen_inv_stage\[47\].inv/I
+ u_core.delay_paths.u_trc0.gen_inv_stage\[48\].inv/I VDD VDD VSS VSS gf180mcu_fd_sc_mcu7t5v0__inv_1
XFILLER_44_427 VDD VDD VSS VSS gf180mcu_fd_sc_mcu7t5v0__fill_2
XTAP_TAPCELL_ROW_54_455 VDD VSS gf180mcu_fd_sc_mcu7t5v0__filltie
XFILLER_12_357 VDD VDD VSS VSS gf180mcu_fd_sc_mcu7t5v0__fill_2
XFILLER_8_317 VDD VDD VSS VSS gf180mcu_fd_sc_mcu7t5v0__fill_2
XFILLER_47_276 VDD VDD VSS VSS gf180mcu_fd_sc_mcu7t5v0__fillcap_4
Xmax_cap71 _685_/RN _686_/RN VDD VDD VSS VSS gf180mcu_fd_sc_mcu7t5v0__buf_2
X_697_ _697_/D _699_/RN _702_/CLK _697_/Q VDD VDD VSS VSS gf180mcu_fd_sc_mcu7t5v0__dffrnq_1
XTAP_TAPCELL_ROW_45_400 VDD VSS gf180mcu_fd_sc_mcu7t5v0__filltie
XFILLER_15_195 VDD VDD VSS VSS gf180mcu_fd_sc_mcu7t5v0__fillcap_8
XFILLER_50_419 VDD VDD VSS VSS gf180mcu_fd_sc_mcu7t5v0__fillcap_8
XFILLER_38_265 VDD VDD VSS VSS gf180mcu_fd_sc_mcu7t5v0__fill_1
XTAP_TAPCELL_ROW_51_436 VDD VSS gf180mcu_fd_sc_mcu7t5v0__filltie
XPHY_EDGE_ROW_5_Right_5 VDD VSS gf180mcu_fd_sc_mcu7t5v0__endcap
XFILLER_21_176 VDD VDD VSS VSS gf180mcu_fd_sc_mcu7t5v0__fill_1
XFILLER_5_309 VDD VDD VSS VSS gf180mcu_fd_sc_mcu7t5v0__fill_1
XPHY_EDGE_ROW_10_Left_71 VDD VSS gf180mcu_fd_sc_mcu7t5v0__endcap
X_620_ _620_/D _695_/RN _694_/CLK _620_/Q VDD VDD VSS VSS gf180mcu_fd_sc_mcu7t5v0__dffrnq_1
X_551_ _658_/Q _659_/Q _570_/A1 VDD VDD VSS VSS gf180mcu_fd_sc_mcu7t5v0__nand2_1
XFILLER_12_143 VDD VDD VSS VSS gf180mcu_fd_sc_mcu7t5v0__fill_1
XFILLER_32_419 VDD VDD VSS VSS gf180mcu_fd_sc_mcu7t5v0__fillcap_8
XFILLER_8_136 VDD VDD VSS VSS gf180mcu_fd_sc_mcu7t5v0__fill_2
X_482_ _667_/Q _494_/A1 _484_/B VDD VDD VSS VSS gf180mcu_fd_sc_mcu7t5v0__nand2_1
XFILLER_32_83 VDD VDD VSS VSS gf180mcu_fd_sc_mcu7t5v0__fill_2
XFILLER_43_290 VDD VDD VSS VSS gf180mcu_fd_sc_mcu7t5v0__fillcap_8
XFILLER_26_257 VDD VDD VSS VSS gf180mcu_fd_sc_mcu7t5v0__fill_1
Xu_core.delay_paths.u_trc3.gen_inv_stage\[38\].inv u_core.delay_paths.u_trc3.gen_inv_stage\[38\].inv/I
+ u_core.delay_paths.u_trc3.gen_inv_stage\[39\].inv/I VDD VDD VSS VSS gf180mcu_fd_sc_mcu7t5v0__inv_1
Xu_core.delay_paths.u_trc3.gen_inv_stage\[23\].inv u_core.delay_paths.u_trc3.gen_inv_stage\[23\].inv/I
+ u_core.delay_paths.u_trc3.gen_inv_stage\[24\].inv/I VDD VDD VSS VSS gf180mcu_fd_sc_mcu7t5v0__inv_1
XFILLER_27_72 VDD VDD VSS VSS gf180mcu_fd_sc_mcu7t5v0__fill_2
X_603_ _603_/D wire28/Z _688_/CLK _603_/Q VDD VDD VSS VSS gf180mcu_fd_sc_mcu7t5v0__dffrnq_1
X_534_ _616_/D _644_/Q _534_/S _644_/D VDD VDD VSS VSS gf180mcu_fd_sc_mcu7t5v0__mux2_2
X_465_ _696_/D _696_/Q _492_/A1 VDD VDD VSS VSS gf180mcu_fd_sc_mcu7t5v0__nor2_1
XFILLER_40_293 VDD VDD VSS VSS gf180mcu_fd_sc_mcu7t5v0__fill_2
X_396_ _514_/A1 _394_/Z _396_/Z VDD VDD VSS VSS gf180mcu_fd_sc_mcu7t5v0__xor2_1
XFILLER_4_65 VDD VDD VSS VSS gf180mcu_fd_sc_mcu7t5v0__fillcap_4
XTAP_TAPCELL_ROW_18_241 VDD VSS gf180mcu_fd_sc_mcu7t5v0__filltie
XFILLER_31_282 VDD VDD VSS VSS gf180mcu_fd_sc_mcu7t5v0__fillcap_4
Xfanout31 _702_/RN _685_/RN VDD VDD VSS VSS gf180mcu_fd_sc_mcu7t5v0__buf_1
Xfanout20 _702_/D _515_/S VDD VDD VSS VSS gf180mcu_fd_sc_mcu7t5v0__buf_1
XTAP_TAPCELL_ROW_24_277 VDD VSS gf180mcu_fd_sc_mcu7t5v0__filltie
XFILLER_1_142 VDD VDD VSS VSS gf180mcu_fd_sc_mcu7t5v0__fill_2
XFILLER_45_352 VDD VDD VSS VSS gf180mcu_fd_sc_mcu7t5v0__fillcap_64
X_517_ _617_/D _694_/Q _517_/S _694_/D VDD VDD VSS VSS gf180mcu_fd_sc_mcu7t5v0__mux2_2
X_448_ _637_/Q _437_/Z _448_/B1 _648_/Q _449_/B2 VDD VDD VSS VSS gf180mcu_fd_sc_mcu7t5v0__aoi22_1
XTAP_TAPCELL_ROW_15_222 VDD VSS gf180mcu_fd_sc_mcu7t5v0__filltie
Xclkload12 _703_/CLK clkload12/Z VDD VDD VSS VSS gf180mcu_fd_sc_mcu7t5v0__clkbuf_2
X_379_ _678_/Q _674_/Q _384_/C VDD VDD VSS VSS gf180mcu_fd_sc_mcu7t5v0__nand2_1
XFILLER_48_2 VDD VDD VSS VSS gf180mcu_fd_sc_mcu7t5v0__fillcap_32
Xu_core.delay_paths.u_trc2.gen_inv_stage\[62\].inv u_core.delay_paths.u_trc2.gen_inv_stage\[62\].inv/I
+ u_core.delay_paths.u_trc2.gen_inv_stage\[63\].inv/I VDD VDD VSS VSS gf180mcu_fd_sc_mcu7t5v0__inv_1
Xu_core.delay_paths.u_trc2.gen_inv_stage\[77\].inv u_core.delay_paths.u_trc2.gen_inv_stage\[77\].inv/I
+ u_core.delay_paths.u_trc2.gen_inv_stage\[78\].inv/I VDD VDD VSS VSS gf180mcu_fd_sc_mcu7t5v0__inv_1
XTAP_TAPCELL_ROW_38_358 VDD VSS gf180mcu_fd_sc_mcu7t5v0__filltie
Xu_core.delay_paths.u_trc2.gen_inv_stage\[15\].inv u_core.delay_paths.u_trc2.gen_inv_stage\[15\].inv/I
+ u_core.delay_paths.u_trc2.gen_inv_stage\[16\].inv/I VDD VDD VSS VSS gf180mcu_fd_sc_mcu7t5v0__inv_1
Xclkload6 _699_/CLK clkload6/Z VDD VDD VSS VSS gf180mcu_fd_sc_mcu7t5v0__clkbuf_2
XTAP_TAPCELL_ROW_21_258 VDD VSS gf180mcu_fd_sc_mcu7t5v0__filltie
XFILLER_3_418 VDD VDD VSS VSS gf180mcu_fd_sc_mcu7t5v0__fill_2
XFILLER_59_422 VDD VDD VSS VSS gf180mcu_fd_sc_mcu7t5v0__fillcap_8
XTAP_TAPCELL_ROW_29_303 VDD VSS gf180mcu_fd_sc_mcu7t5v0__filltie
XFILLER_27_352 VDD VDD VSS VSS gf180mcu_fd_sc_mcu7t5v0__fillcap_4
XFILLER_54_171 VDD VDD VSS VSS gf180mcu_fd_sc_mcu7t5v0__fillcap_4
X_302_ _720_/I _606_/D VDD VDD VSS VSS gf180mcu_fd_sc_mcu7t5v0__clkinv_1
XFILLER_40_61 VDD VDD VSS VSS gf180mcu_fd_sc_mcu7t5v0__fill_2
XFILLER_6_223 VDD VDD VSS VSS gf180mcu_fd_sc_mcu7t5v0__fill_2
XTAP_TAPCELL_ROW_12_203 VDD VSS gf180mcu_fd_sc_mcu7t5v0__filltie
Xu_core.delay_paths.u_trc1.gen_inv_stage\[102\].inv u_core.delay_paths.u_trc1.gen_inv_stage\[102\].inv/I
+ u_core.delay_paths.u_trc1.gen_inv_stage\[103\].inv/I VDD VDD VSS VSS gf180mcu_fd_sc_mcu7t5v0__inv_1
XTAP_TAPCELL_ROW_35_339 VDD VSS gf180mcu_fd_sc_mcu7t5v0__filltie
Xu_core.delay_paths.u_trc1.gen_inv_stage\[117\].inv u_core.delay_paths.u_trc1.gen_inv_stage\[117\].inv/I
+ u_core.delay_paths.u_trc1.gen_inv_stage\[118\].inv/I VDD VDD VSS VSS gf180mcu_fd_sc_mcu7t5v0__inv_1
XFILLER_28_138 VDD VDD VSS VSS gf180mcu_fd_sc_mcu7t5v0__fill_2
XFILLER_19_138 VDD VDD VSS VSS gf180mcu_fd_sc_mcu7t5v0__fill_2
XTAP_TAPCELL_ROW_57_475 VDD VSS gf180mcu_fd_sc_mcu7t5v0__filltie
XFILLER_27_182 VDD VDD VSS VSS gf180mcu_fd_sc_mcu7t5v0__fillcap_8
XFILLER_35_72 VDD VDD VSS VSS gf180mcu_fd_sc_mcu7t5v0__fillcap_8
Xu_core.delay_paths.u_trc1.gen_inv_stage\[7\].inv u_core.delay_paths.u_trc1.gen_inv_stage\[7\].inv/I
+ u_core.delay_paths.u_trc1.gen_inv_stage\[8\].inv/I VDD VDD VSS VSS gf180mcu_fd_sc_mcu7t5v0__inv_1
Xu_core.delay_paths.u_trc3.gen_inv_stage\[6\].inv u_core.delay_paths.u_trc3.gen_inv_stage\[6\].inv/I
+ u_core.delay_paths.u_trc3.gen_inv_stage\[7\].inv/I VDD VDD VSS VSS gf180mcu_fd_sc_mcu7t5v0__inv_1
XFILLER_18_193 VDD VDD VSS VSS gf180mcu_fd_sc_mcu7t5v0__fill_1
XFILLER_33_163 VDD VDD VSS VSS gf180mcu_fd_sc_mcu7t5v0__fillcap_8
Xu_core.delay_paths.u_trc1.gen_inv_stage\[54\].inv u_core.delay_paths.u_trc1.gen_inv_stage\[54\].inv/I
+ u_core.delay_paths.u_trc1.gen_inv_stage\[55\].inv/I VDD VDD VSS VSS gf180mcu_fd_sc_mcu7t5v0__inv_1
XTAP_TAPCELL_ROW_48_420 VDD VSS gf180mcu_fd_sc_mcu7t5v0__filltie
Xu_core.delay_paths.u_trc1.gen_inv_stage\[69\].inv u_core.delay_paths.u_trc1.gen_inv_stage\[69\].inv/I
+ u_core.delay_paths.u_trc1.gen_inv_stage\[70\].inv/I VDD VDD VSS VSS gf180mcu_fd_sc_mcu7t5v0__inv_1
XTAP_TAPCELL_ROW_54_456 VDD VSS gf180mcu_fd_sc_mcu7t5v0__filltie
X_696_ _696_/D _700_/RN _705_/CLK _696_/Q VDD VDD VSS VSS gf180mcu_fd_sc_mcu7t5v0__dffsnq_1
XTAP_TAPCELL_ROW_45_401 VDD VSS gf180mcu_fd_sc_mcu7t5v0__filltie
XFILLER_30_177 VDD VDD VSS VSS gf180mcu_fd_sc_mcu7t5v0__fillcap_4
XFILLER_30_2 VDD VDD VSS VSS gf180mcu_fd_sc_mcu7t5v0__fillcap_32
XFILLER_7_395 VDD VDD VSS VSS gf180mcu_fd_sc_mcu7t5v0__fill_2
XFILLER_38_233 VDD VDD VSS VSS gf180mcu_fd_sc_mcu7t5v0__fillcap_4
XFILLER_38_244 VDD VDD VSS VSS gf180mcu_fd_sc_mcu7t5v0__fill_1
XFILLER_38_255 VDD VDD VSS VSS gf180mcu_fd_sc_mcu7t5v0__fillcap_8
XTAP_TAPCELL_ROW_51_437 VDD VSS gf180mcu_fd_sc_mcu7t5v0__filltie
XFILLER_21_199 VDD VDD VSS VSS gf180mcu_fd_sc_mcu7t5v0__fillcap_8
Xu_core.delay_paths.u_trc0.gen_inv_stage\[142\].inv u_core.delay_paths.u_trc0.gen_inv_stage\[142\].inv/I
+ u_core.delay_paths.u_trc0.gen_inv_stage\[143\].inv/I VDD VDD VSS VSS gf180mcu_fd_sc_mcu7t5v0__inv_1
Xu_core.delay_paths.u_trc0.gen_inv_stage\[157\].inv u_core.delay_paths.u_trc0.gen_inv_stage\[157\].inv/I
+ u_core.delay_paths.u_trc0.gen_inv_stage\[158\].inv/I VDD VDD VSS VSS gf180mcu_fd_sc_mcu7t5v0__inv_1
XFILLER_29_277 VDD VDD VSS VSS gf180mcu_fd_sc_mcu7t5v0__fill_2
X_550_ _584_/A1 _699_/Q _550_/B _655_/D VDD VDD VSS VSS gf180mcu_fd_sc_mcu7t5v0__aoi21_1
X_481_ _700_/Q _483_/A2 _481_/B _494_/A1 VDD VDD VSS VSS gf180mcu_fd_sc_mcu7t5v0__aoi21_1
XFILLER_12_177 VDD VDD VSS VSS gf180mcu_fd_sc_mcu7t5v0__fill_1
XFILLER_8_115 VDD VDD VSS VSS gf180mcu_fd_sc_mcu7t5v0__fillcap_4
XPHY_EDGE_ROW_11_Right_11 VDD VSS gf180mcu_fd_sc_mcu7t5v0__endcap
XFILLER_32_95 VDD VDD VSS VSS gf180mcu_fd_sc_mcu7t5v0__fillcap_8
XFILLER_4_365 VDD VDD VSS VSS gf180mcu_fd_sc_mcu7t5v0__fillcap_8
Xu_core.delay_paths.u_trc0.gen_inv_stage\[93\].inv u_core.delay_paths.u_trc0.gen_inv_stage\[93\].inv/I
+ u_core.delay_paths.u_trc0.gen_inv_stage\[94\].inv/I VDD VDD VSS VSS gf180mcu_fd_sc_mcu7t5v0__inv_2
XPHY_EDGE_ROW_20_Right_20 VDD VSS gf180mcu_fd_sc_mcu7t5v0__endcap
XTAP_TAPCELL_ROW_7_170 VDD VSS gf180mcu_fd_sc_mcu7t5v0__filltie
XFILLER_23_409 VDD VDD VSS VSS gf180mcu_fd_sc_mcu7t5v0__fill_2
Xu_core.delay_paths.u_trc0.gen_inv_stage\[31\].inv u_core.delay_paths.u_trc0.gen_inv_stage\[31\].inv/I
+ u_core.delay_paths.u_trc0.gen_inv_stage\[32\].inv/I VDD VDD VSS VSS gf180mcu_fd_sc_mcu7t5v0__inv_1
X_679_ _679_/D _700_/RN _700_/CLK _679_/Q VDD VDD VSS VSS gf180mcu_fd_sc_mcu7t5v0__dffrnq_1
Xu_core.delay_paths.u_trc0.gen_inv_stage\[46\].inv u_core.delay_paths.u_trc0.gen_inv_stage\[46\].inv/I
+ u_core.delay_paths.u_trc0.gen_inv_stage\[47\].inv/I VDD VDD VSS VSS gf180mcu_fd_sc_mcu7t5v0__inv_1
XFILLER_58_317 VDD VDD VSS VSS gf180mcu_fd_sc_mcu7t5v0__fillcap_64
X_602_ _602_/I _633_/RN VDD VDD VSS VSS gf180mcu_fd_sc_mcu7t5v0__clkinv_1
XFILLER_17_214 VDD VDD VSS VSS gf180mcu_fd_sc_mcu7t5v0__fill_1
XFILLER_25_291 VDD VDD VSS VSS gf180mcu_fd_sc_mcu7t5v0__fillcap_4
X_533_ _615_/D _643_/Q _533_/S _643_/D VDD VDD VSS VSS gf180mcu_fd_sc_mcu7t5v0__mux2_2
X_464_ _480_/A1 _464_/A2 _464_/B _662_/D VDD VDD VSS VSS gf180mcu_fd_sc_mcu7t5v0__aoi21_1
XFILLER_43_72 VDD VDD VSS VSS gf180mcu_fd_sc_mcu7t5v0__fillcap_16
X_395_ _685_/Q _395_/A2 wire17/Z _397_/B VDD VDD VSS VSS gf180mcu_fd_sc_mcu7t5v0__xor3_1
XFILLER_4_173 VDD VDD VSS VSS gf180mcu_fd_sc_mcu7t5v0__fill_2
XFILLER_4_195 VDD VDD VSS VSS gf180mcu_fd_sc_mcu7t5v0__fill_1
XFILLER_4_22 VDD VDD VSS VSS gf180mcu_fd_sc_mcu7t5v0__fillcap_8
XFILLER_14_217 VDD VDD VSS VSS gf180mcu_fd_sc_mcu7t5v0__fillcap_16
Xfanout21 _702_/D _509_/S VDD VDD VSS VSS gf180mcu_fd_sc_mcu7t5v0__dlyb_1
XFILLER_22_283 VDD VDD VSS VSS gf180mcu_fd_sc_mcu7t5v0__fillcap_8
Xfanout43 _666_/RN _693_/RN VDD VDD VSS VSS gf180mcu_fd_sc_mcu7t5v0__dlyb_1
Xfanout32 _702_/RN _699_/RN VDD VDD VSS VSS gf180mcu_fd_sc_mcu7t5v0__dlyb_1
XFILLER_8_2 VDD VDD VSS VSS gf180mcu_fd_sc_mcu7t5v0__fillcap_32
X_516_ _692_/Q _693_/D _692_/D VDD VDD VSS VSS gf180mcu_fd_sc_mcu7t5v0__or2_1
X_447_ _689_/Q _447_/A2 _453_/B _451_/B1 VDD VDD VSS VSS gf180mcu_fd_sc_mcu7t5v0__aoi21_1
X_378_ _681_/Q _377_/Z _378_/B _384_/A1 VDD VDD VSS VSS gf180mcu_fd_sc_mcu7t5v0__aoi21_1
XTAP_TAPCELL_ROW_15_223 VDD VSS gf180mcu_fd_sc_mcu7t5v0__filltie
Xu_core.delay_paths.u_trc3.gen_inv_stage\[22\].inv u_core.delay_paths.u_trc3.gen_inv_stage\[22\].inv/I
+ u_core.delay_paths.u_trc3.gen_inv_stage\[23\].inv/I VDD VDD VSS VSS gf180mcu_fd_sc_mcu7t5v0__inv_1
Xclkload13 _692_/CLK clkload13/Z VDD VDD VSS VSS gf180mcu_fd_sc_mcu7t5v0__clkbuf_2
Xu_core.delay_paths.u_trc3.gen_inv_stage\[37\].inv u_core.delay_paths.u_trc3.gen_inv_stage\[37\].inv/I
+ u_core.delay_paths.u_trc3.gen_inv_stage\[38\].inv/I VDD VDD VSS VSS gf180mcu_fd_sc_mcu7t5v0__inv_1
XFILLER_36_353 VDD VDD VSS VSS gf180mcu_fd_sc_mcu7t5v0__fillcap_32
XTAP_TAPCELL_ROW_38_359 VDD VSS gf180mcu_fd_sc_mcu7t5v0__filltie
XFILLER_11_209 VDD VDD VSS VSS gf180mcu_fd_sc_mcu7t5v0__fill_1
Xclkload7 _702_/CLK clkload7/Z VDD VDD VSS VSS gf180mcu_fd_sc_mcu7t5v0__clkbuf_2
XTAP_TAPCELL_ROW_21_259 VDD VSS gf180mcu_fd_sc_mcu7t5v0__filltie
XFILLER_27_320 VDD VDD VSS VSS gf180mcu_fd_sc_mcu7t5v0__fill_2
XFILLER_46_139 VDD VDD VSS VSS gf180mcu_fd_sc_mcu7t5v0__fillcap_4
XTAP_TAPCELL_ROW_29_304 VDD VSS gf180mcu_fd_sc_mcu7t5v0__filltie
XFILLER_24_85 VDD VDD VSS VSS gf180mcu_fd_sc_mcu7t5v0__fillcap_8
X_301_ _718_/I _604_/D VDD VDD VSS VSS gf180mcu_fd_sc_mcu7t5v0__clkinv_1
XTAP_TAPCELL_ROW_12_204 VDD VSS gf180mcu_fd_sc_mcu7t5v0__filltie
XFILLER_10_242 VDD VDD VSS VSS gf180mcu_fd_sc_mcu7t5v0__fill_2
XFILLER_10_297 VDD VDD VSS VSS gf180mcu_fd_sc_mcu7t5v0__fillcap_16
XFILLER_18_375 VDD VDD VSS VSS gf180mcu_fd_sc_mcu7t5v0__fill_1
XFILLER_37_139 VDD VDD VSS VSS gf180mcu_fd_sc_mcu7t5v0__fill_1
XFILLER_5_290 VDD VDD VSS VSS gf180mcu_fd_sc_mcu7t5v0__fill_2
XFILLER_60_2 VDD VDD VSS VSS gf180mcu_fd_sc_mcu7t5v0__fillcap_4
XPHY_EDGE_ROW_49_Right_49 VDD VSS gf180mcu_fd_sc_mcu7t5v0__endcap
XPHY_EDGE_ROW_58_Right_58 VDD VSS gf180mcu_fd_sc_mcu7t5v0__endcap
XFILLER_24_367 VDD VDD VSS VSS gf180mcu_fd_sc_mcu7t5v0__fill_1
XFILLER_51_142 VDD VDD VSS VSS gf180mcu_fd_sc_mcu7t5v0__fillcap_64
XFILLER_19_96 VDD VDD VSS VSS gf180mcu_fd_sc_mcu7t5v0__fillcap_4
XFILLER_27_194 VDD VDD VSS VSS gf180mcu_fd_sc_mcu7t5v0__fill_2
XFILLER_35_84 VDD VDD VSS VSS gf180mcu_fd_sc_mcu7t5v0__fill_2
XFILLER_51_72 VDD VDD VSS VSS gf180mcu_fd_sc_mcu7t5v0__fillcap_64
Xu_core.delay_paths.u_trc2.gen_inv_stage\[61\].inv u_core.delay_paths.u_trc2.gen_inv_stage\[61\].inv/I
+ u_core.delay_paths.u_trc2.gen_inv_stage\[62\].inv/I VDD VDD VSS VSS gf180mcu_fd_sc_mcu7t5v0__inv_1
Xu_core.delay_paths.u_trc2.gen_inv_stage\[76\].inv u_core.delay_paths.u_trc2.gen_inv_stage\[76\].inv/I
+ u_core.delay_paths.u_trc2.gen_inv_stage\[77\].inv/I VDD VDD VSS VSS gf180mcu_fd_sc_mcu7t5v0__inv_1
Xu_core.delay_paths.u_trc2.gen_inv_stage\[14\].inv u_core.delay_paths.u_trc2.gen_inv_stage\[14\].inv/I
+ u_core.delay_paths.u_trc2.gen_inv_stage\[15\].inv/I VDD VDD VSS VSS gf180mcu_fd_sc_mcu7t5v0__inv_1
XTAP_TAPCELL_ROW_48_421 VDD VSS gf180mcu_fd_sc_mcu7t5v0__filltie
XFILLER_21_337 VDD VDD VSS VSS gf180mcu_fd_sc_mcu7t5v0__fill_1
XFILLER_33_131 VDD VDD VSS VSS gf180mcu_fd_sc_mcu7t5v0__fillcap_8
XFILLER_33_175 VDD VDD VSS VSS gf180mcu_fd_sc_mcu7t5v0__fill_1
Xu_core.delay_paths.u_trc2.gen_inv_stage\[29\].inv u_core.delay_paths.u_trc2.gen_inv_stage\[29\].inv/I
+ u_core.delay_paths.u_trc2.gen_inv_stage\[30\].inv/I VDD VDD VSS VSS gf180mcu_fd_sc_mcu7t5v0__inv_1
XFILLER_44_429 VDD VDD VSS VSS gf180mcu_fd_sc_mcu7t5v0__fill_1
XFILLER_12_359 VDD VDD VSS VSS gf180mcu_fd_sc_mcu7t5v0__fill_1
XTAP_TAPCELL_ROW_54_457 VDD VSS gf180mcu_fd_sc_mcu7t5v0__filltie
XFILLER_47_212 VDD VDD VSS VSS gf180mcu_fd_sc_mcu7t5v0__fillcap_64
Xu_core.delay_paths.u_trc1.gen_inv_stage\[101\].inv u_core.delay_paths.u_trc1.gen_inv_stage\[101\].inv/I
+ u_core.delay_paths.u_trc1.gen_inv_stage\[102\].inv/I VDD VDD VSS VSS gf180mcu_fd_sc_mcu7t5v0__inv_1
XFILLER_15_131 VDD VDD VSS VSS gf180mcu_fd_sc_mcu7t5v0__fillcap_8
XFILLER_15_142 VDD VDD VSS VSS gf180mcu_fd_sc_mcu7t5v0__fillcap_16
XFILLER_35_418 VDD VDD VSS VSS gf180mcu_fd_sc_mcu7t5v0__fill_2
Xu_core.delay_paths.u_trc1.gen_inv_stage\[116\].inv u_core.delay_paths.u_trc1.gen_inv_stage\[116\].inv/I
+ u_core.delay_paths.u_trc1.gen_inv_stage\[117\].inv/I VDD VDD VSS VSS gf180mcu_fd_sc_mcu7t5v0__inv_1
Xmax_cap73 _547_/A1 _696_/D VDD VDD VSS VSS gf180mcu_fd_sc_mcu7t5v0__buf_2
X_695_ _695_/D _695_/RN _695_/CLK _695_/Q VDD VDD VSS VSS gf180mcu_fd_sc_mcu7t5v0__dffrnq_1
XTAP_TAPCELL_ROW_45_402 VDD VSS gf180mcu_fd_sc_mcu7t5v0__filltie
XFILLER_7_352 VDD VDD VSS VSS gf180mcu_fd_sc_mcu7t5v0__fillcap_8
XFILLER_7_66 VDD VDD VSS VSS gf180mcu_fd_sc_mcu7t5v0__fillcap_4
XFILLER_23_2 VDD VDD VSS VSS gf180mcu_fd_sc_mcu7t5v0__fillcap_64
XTAP_TAPCELL_ROW_51_438 VDD VSS gf180mcu_fd_sc_mcu7t5v0__filltie
Xu_core.delay_paths.u_trc1.gen_inv_stage\[6\].inv u_core.delay_paths.u_trc1.gen_inv_stage\[6\].inv/I
+ u_core.delay_paths.u_trc1.gen_inv_stage\[7\].inv/I VDD VDD VSS VSS gf180mcu_fd_sc_mcu7t5v0__inv_1
XFILLER_29_212 VDD VDD VSS VSS gf180mcu_fd_sc_mcu7t5v0__fillcap_4
XPHY_EDGE_ROW_48_Left_109 VDD VSS gf180mcu_fd_sc_mcu7t5v0__endcap
XFILLER_17_418 VDD VDD VSS VSS gf180mcu_fd_sc_mcu7t5v0__fill_2
X_480_ _480_/A1 _462_/Z _492_/A2 _483_/A2 VDD VDD VSS VSS gf180mcu_fd_sc_mcu7t5v0__nand3_1
XFILLER_8_138 VDD VDD VSS VSS gf180mcu_fd_sc_mcu7t5v0__fill_1
Xu_core.delay_paths.u_trc3.gen_inv_stage\[5\].inv u_core.delay_paths.u_trc3.gen_inv_stage\[5\].inv/I
+ u_core.delay_paths.u_trc3.gen_inv_stage\[6\].inv/I VDD VDD VSS VSS gf180mcu_fd_sc_mcu7t5v0__inv_1
XPHY_EDGE_ROW_57_Left_118 VDD VSS gf180mcu_fd_sc_mcu7t5v0__endcap
XFILLER_4_311 VDD VDD VSS VSS gf180mcu_fd_sc_mcu7t5v0__fillcap_4
XFILLER_4_377 VDD VDD VSS VSS gf180mcu_fd_sc_mcu7t5v0__fill_1
Xu_core.delay_paths.u_trc1.gen_inv_stage\[53\].inv u_core.delay_paths.u_trc1.gen_inv_stage\[53\].inv/I
+ u_core.delay_paths.u_trc1.gen_inv_stage\[54\].inv/I VDD VDD VSS VSS gf180mcu_fd_sc_mcu7t5v0__inv_1
Xu_core.delay_paths.u_trc1.gen_inv_stage\[68\].inv u_core.delay_paths.u_trc1.gen_inv_stage\[68\].inv/I
+ u_core.delay_paths.u_trc1.gen_inv_stage\[69\].inv/I VDD VDD VSS VSS gf180mcu_fd_sc_mcu7t5v0__inv_1
XTAP_TAPCELL_ROW_7_171 VDD VSS gf180mcu_fd_sc_mcu7t5v0__filltie
X_678_ _678_/D _686_/RN _682_/CLK _678_/Q VDD VDD VSS VSS gf180mcu_fd_sc_mcu7t5v0__dffrnq_1
XFILLER_17_204 VDD VDD VSS VSS gf180mcu_fd_sc_mcu7t5v0__fillcap_4
X_601_ _601_/I _632_/RN VDD VDD VSS VSS gf180mcu_fd_sc_mcu7t5v0__clkinv_1
XTAP_TAPCELL_ROW_4_152 VDD VSS gf180mcu_fd_sc_mcu7t5v0__filltie
X_532_ _614_/D _642_/Q _533_/S _642_/D VDD VDD VSS VSS gf180mcu_fd_sc_mcu7t5v0__mux2_2
X_463_ _464_/A2 _462_/Z _464_/B VDD VDD VSS VSS gf180mcu_fd_sc_mcu7t5v0__nor2_1
X_394_ _395_/A2 wire17/Z _394_/Z VDD VDD VSS VSS gf180mcu_fd_sc_mcu7t5v0__xor2_1
XFILLER_40_273 VDD VDD VSS VSS gf180mcu_fd_sc_mcu7t5v0__fillcap_16
XFILLER_4_34 VDD VDD VSS VSS gf180mcu_fd_sc_mcu7t5v0__fill_1
Xu_core.delay_paths.u_trc0.gen_inv_stage\[141\].inv u_core.delay_paths.u_trc0.gen_inv_stage\[141\].inv/I
+ u_core.delay_paths.u_trc0.gen_inv_stage\[142\].inv/I VDD VDD VSS VSS gf180mcu_fd_sc_mcu7t5v0__inv_1
Xu_core.delay_paths.u_trc0.gen_inv_stage\[156\].inv u_core.delay_paths.u_trc0.gen_inv_stage\[156\].inv/I
+ u_core.delay_paths.u_trc0.gen_inv_stage\[157\].inv/I VDD VDD VSS VSS gf180mcu_fd_sc_mcu7t5v0__inv_1
Xu_core.delay_paths.u_trc0.gen_inv_stage\[109\].inv u_core.delay_paths.u_trc0.gen_inv_stage\[109\].inv/I
+ u_core.delay_paths.u_trc0.gen_inv_stage\[110\].inv/I VDD VDD VSS VSS gf180mcu_fd_sc_mcu7t5v0__inv_2
XFILLER_54_387 VDD VDD VSS VSS gf180mcu_fd_sc_mcu7t5v0__fillcap_32
Xu_core.delay_paths.u_trc0.gen_inv_stage\[92\].inv u_core.delay_paths.u_trc0.gen_inv_stage\[92\].inv/I
+ u_core.delay_paths.u_trc0.gen_inv_stage\[93\].inv/I VDD VDD VSS VSS gf180mcu_fd_sc_mcu7t5v0__inv_2
Xfanout44 input1/Z _666_/RN VDD VDD VSS VSS gf180mcu_fd_sc_mcu7t5v0__dlyb_1
Xfanout22 _698_/Q wire72/I VDD VDD VSS VSS gf180mcu_fd_sc_mcu7t5v0__buf_1
XFILLER_13_76 VDD VDD VSS VSS gf180mcu_fd_sc_mcu7t5v0__fill_2
XFILLER_6_428 VDD VDD VSS VSS gf180mcu_fd_sc_mcu7t5v0__fill_2
XFILLER_1_100 VDD VDD VSS VSS gf180mcu_fd_sc_mcu7t5v0__fill_2
XFILLER_1_122 VDD VDD VSS VSS gf180mcu_fd_sc_mcu7t5v0__fill_2
XFILLER_1_144 VDD VDD VSS VSS gf180mcu_fd_sc_mcu7t5v0__fill_1
XFILLER_49_104 VDD VDD VSS VSS gf180mcu_fd_sc_mcu7t5v0__fillcap_4
Xu_core.delay_paths.u_trc0.gen_inv_stage\[30\].inv u_core.delay_paths.u_trc0.gen_inv_stage\[30\].inv/I
+ u_core.delay_paths.u_trc0.gen_inv_stage\[31\].inv/I VDD VDD VSS VSS gf180mcu_fd_sc_mcu7t5v0__inv_1
Xu_core.delay_paths.u_trc0.gen_inv_stage\[45\].inv u_core.delay_paths.u_trc0.gen_inv_stage\[45\].inv/I
+ u_core.delay_paths.u_trc0.gen_inv_stage\[46\].inv/I VDD VDD VSS VSS gf180mcu_fd_sc_mcu7t5v0__inv_1
X_515_ _686_/Q _682_/Q _515_/S _686_/D VDD VDD VSS VSS gf180mcu_fd_sc_mcu7t5v0__mux2_2
X_446_ _446_/A1 _453_/B _446_/B1 _446_/B2 _629_/D VDD VDD VSS VSS gf180mcu_fd_sc_mcu7t5v0__aoi22_1
X_377_ _677_/Q _673_/Q _377_/Z VDD VDD VSS VSS gf180mcu_fd_sc_mcu7t5v0__xor2_1
XFILLER_9_277 VDD VDD VSS VSS gf180mcu_fd_sc_mcu7t5v0__fill_2
Xclkload14 _693_/CLK clkload14/Z VDD VDD VSS VSS gf180mcu_fd_sc_mcu7t5v0__clkbuf_2
XFILLER_36_387 VDD VDD VSS VSS gf180mcu_fd_sc_mcu7t5v0__fillcap_32
XFILLER_51_346 VDD VDD VSS VSS gf180mcu_fd_sc_mcu7t5v0__fillcap_4
Xclkload8 _644_/CLK clkload8/Z VDD VDD VSS VSS gf180mcu_fd_sc_mcu7t5v0__clkbuf_2
XFILLER_46_107 VDD VDD VSS VSS gf180mcu_fd_sc_mcu7t5v0__fillcap_32
XTAP_TAPCELL_ROW_29_305 VDD VSS gf180mcu_fd_sc_mcu7t5v0__filltie
X_300_ _634_/Q _522_/A1 VDD VDD VSS VSS gf180mcu_fd_sc_mcu7t5v0__clkinv_1
XTAP_TAPCELL_ROW_12_205 VDD VSS gf180mcu_fd_sc_mcu7t5v0__filltie
XFILLER_6_247 VDD VDD VSS VSS gf180mcu_fd_sc_mcu7t5v0__fillcap_8
XFILLER_49_72 VDD VDD VSS VSS gf180mcu_fd_sc_mcu7t5v0__fillcap_32
XFILLER_18_387 VDD VDD VSS VSS gf180mcu_fd_sc_mcu7t5v0__fill_2
XFILLER_33_313 VDD VDD VSS VSS gf180mcu_fd_sc_mcu7t5v0__fillcap_4
XFILLER_60_154 VDD VDD VSS VSS gf180mcu_fd_sc_mcu7t5v0__fillcap_4
X_429_ _464_/A2 _429_/A2 _430_/I VDD VDD VSS VSS gf180mcu_fd_sc_mcu7t5v0__or2_1
XFILLER_53_2 VDD VDD VSS VSS gf180mcu_fd_sc_mcu7t5v0__fillcap_64
XFILLER_28_107 VDD VDD VSS VSS gf180mcu_fd_sc_mcu7t5v0__fillcap_8
XFILLER_36_162 VDD VDD VSS VSS gf180mcu_fd_sc_mcu7t5v0__fill_1
XFILLER_56_427 VDD VDD VSS VSS gf180mcu_fd_sc_mcu7t5v0__fill_2
Xinput1 iRST input1/Z VDD VDD VSS VSS gf180mcu_fd_sc_mcu7t5v0__dlyb_1
XFILLER_3_228 VDD VDD VSS VSS gf180mcu_fd_sc_mcu7t5v0__fillcap_8
Xclkbuf_4_14__f_iCLK clkbuf_0_iCLK/Z _692_/CLK VDD VDD VSS VSS gf180mcu_fd_sc_mcu7t5v0__clkbuf_16
XFILLER_10_77 VDD VDD VSS VSS gf180mcu_fd_sc_mcu7t5v0__fillcap_4
XFILLER_19_107 VDD VDD VSS VSS gf180mcu_fd_sc_mcu7t5v0__fill_2
XFILLER_47_416 VDD VDD VSS VSS gf180mcu_fd_sc_mcu7t5v0__fillcap_4
XFILLER_59_276 VDD VDD VSS VSS gf180mcu_fd_sc_mcu7t5v0__fillcap_4
XFILLER_15_368 VDD VDD VSS VSS gf180mcu_fd_sc_mcu7t5v0__fill_2
XFILLER_27_173 VDD VDD VSS VSS gf180mcu_fd_sc_mcu7t5v0__fill_1
Xu_core.delay_paths.u_trc3.gen_inv_stage\[21\].inv u_core.delay_paths.u_trc3.gen_inv_stage\[21\].inv/I
+ u_core.delay_paths.u_trc3.gen_inv_stage\[22\].inv/I VDD VDD VSS VSS gf180mcu_fd_sc_mcu7t5v0__inv_1
Xu_core.delay_paths.u_trc3.gen_inv_stage\[36\].inv u_core.delay_paths.u_trc3.gen_inv_stage\[36\].inv/I
+ u_core.delay_paths.u_trc3.gen_inv_stage\[37\].inv/I VDD VDD VSS VSS gf180mcu_fd_sc_mcu7t5v0__inv_1
XPHY_EDGE_ROW_27_Left_88 VDD VSS gf180mcu_fd_sc_mcu7t5v0__endcap
XFILLER_38_427 VDD VDD VSS VSS gf180mcu_fd_sc_mcu7t5v0__fill_2
XFILLER_44_419 VDD VDD VSS VSS gf180mcu_fd_sc_mcu7t5v0__fillcap_8
XFILLER_20_382 VDD VDD VSS VSS gf180mcu_fd_sc_mcu7t5v0__fill_2
X_694_ _694_/D _695_/RN _694_/CLK _694_/Q VDD VDD VSS VSS gf180mcu_fd_sc_mcu7t5v0__dffrnq_1
XFILLER_15_110 VDD VDD VSS VSS gf180mcu_fd_sc_mcu7t5v0__fill_1
XFILLER_30_102 VDD VDD VSS VSS gf180mcu_fd_sc_mcu7t5v0__fill_2
XTAP_TAPCELL_ROW_45_403 VDD VSS gf180mcu_fd_sc_mcu7t5v0__filltie
XFILLER_16_2 VDD VDD VSS VSS gf180mcu_fd_sc_mcu7t5v0__fillcap_32
XFILLER_38_279 VDD VDD VSS VSS gf180mcu_fd_sc_mcu7t5v0__fill_2
XFILLER_21_135 VDD VDD VSS VSS gf180mcu_fd_sc_mcu7t5v0__fill_1
XTAP_TAPCELL_ROW_51_439 VDD VSS gf180mcu_fd_sc_mcu7t5v0__filltie
XFILLER_29_279 VDD VDD VSS VSS gf180mcu_fd_sc_mcu7t5v0__fill_1
Xu_core.delay_paths.u_trc2.gen_inv_stage\[60\].inv u_core.delay_paths.u_trc2.gen_inv_stage\[60\].inv/I
+ u_core.delay_paths.u_trc2.gen_inv_stage\[61\].inv/I VDD VDD VSS VSS gf180mcu_fd_sc_mcu7t5v0__inv_1
XFILLER_44_238 VDD VDD VSS VSS gf180mcu_fd_sc_mcu7t5v0__fillcap_4
Xu_core.delay_paths.u_trc2.gen_inv_stage\[75\].inv u_core.delay_paths.u_trc2.gen_inv_stage\[75\].inv/I
+ u_core.delay_paths.u_trc2.gen_inv_stage\[76\].inv/I VDD VDD VSS VSS gf180mcu_fd_sc_mcu7t5v0__inv_1
Xu_core.delay_paths.u_trc2.gen_inv_stage\[13\].inv u_core.delay_paths.u_trc2.gen_inv_stage\[13\].inv/I
+ u_core.delay_paths.u_trc2.gen_inv_stage\[14\].inv/I VDD VDD VSS VSS gf180mcu_fd_sc_mcu7t5v0__inv_1
Xu_core.delay_paths.u_trc2.gen_inv_stage\[28\].inv u_core.delay_paths.u_trc2.gen_inv_stage\[28\].inv/I
+ u_core.delay_paths.u_trc2.gen_inv_stage\[29\].inv/I VDD VDD VSS VSS gf180mcu_fd_sc_mcu7t5v0__inv_1
XTAP_TAPCELL_ROW_7_172 VDD VSS gf180mcu_fd_sc_mcu7t5v0__filltie
XFILLER_57_72 VDD VDD VSS VSS gf180mcu_fd_sc_mcu7t5v0__fillcap_64
X_677_ _677_/D _677_/RN _685_/CLK _677_/Q VDD VDD VSS VSS gf180mcu_fd_sc_mcu7t5v0__dffrnq_1
XFILLER_31_422 VDD VDD VSS VSS gf180mcu_fd_sc_mcu7t5v0__fillcap_8
XPHY_EDGE_ROW_9_Right_9 VDD VSS gf180mcu_fd_sc_mcu7t5v0__endcap
XPHY_EDGE_ROW_14_Left_75 VDD VSS gf180mcu_fd_sc_mcu7t5v0__endcap
Xu_core.delay_paths.u_trc1.gen_inv_stage\[100\].inv u_core.delay_paths.u_trc1.gen_inv_stage\[99\].inv/ZN
+ u_core.delay_paths.u_trc1.gen_inv_stage\[101\].inv/I VDD VDD VSS VSS gf180mcu_fd_sc_mcu7t5v0__inv_1
Xu_core.delay_paths.u_trc1.gen_inv_stage\[115\].inv u_core.delay_paths.u_trc1.gen_inv_stage\[115\].inv/I
+ u_core.delay_paths.u_trc1.gen_inv_stage\[116\].inv/I VDD VDD VSS VSS gf180mcu_fd_sc_mcu7t5v0__inv_1
XFILLER_57_352 VDD VDD VSS VSS gf180mcu_fd_sc_mcu7t5v0__fillcap_64
X_600_ _601_/I _631_/RN VDD VDD VSS VSS gf180mcu_fd_sc_mcu7t5v0__clkinv_1
X_531_ _613_/D _641_/Q _534_/S _641_/D VDD VDD VSS VSS gf180mcu_fd_sc_mcu7t5v0__mux2_2
XTAP_TAPCELL_ROW_4_153 VDD VSS gf180mcu_fd_sc_mcu7t5v0__filltie
XFILLER_13_422 VDD VDD VSS VSS gf180mcu_fd_sc_mcu7t5v0__fillcap_8
XFILLER_25_282 VDD VDD VSS VSS gf180mcu_fd_sc_mcu7t5v0__fill_1
XFILLER_32_208 VDD VDD VSS VSS gf180mcu_fd_sc_mcu7t5v0__fill_2
XFILLER_40_263 VDD VDD VSS VSS gf180mcu_fd_sc_mcu7t5v0__fillcap_4
XFILLER_43_96 VDD VDD VSS VSS gf180mcu_fd_sc_mcu7t5v0__fillcap_4
X_462_ _603_/Q _605_/Q _607_/Q _609_/Q _656_/Q _657_/Q _462_/Z VDD VDD VSS VSS gf180mcu_fd_sc_mcu7t5v0__mux4_1
X_393_ _395_/A2 wire17/Z _400_/A2 VDD VDD VSS VSS gf180mcu_fd_sc_mcu7t5v0__nor2_1
XFILLER_9_426 VDD VDD VSS VSS gf180mcu_fd_sc_mcu7t5v0__fillcap_4
XTAP_TAPCELL_ROW_10_188 VDD VSS gf180mcu_fd_sc_mcu7t5v0__filltie
Xu_core.delay_paths.u_trc1.gen_inv_stage\[5\].inv u_core.delay_paths.u_trc1.gen_inv_stage\[5\].inv/I
+ u_core.delay_paths.u_trc1.gen_inv_stage\[6\].inv/I VDD VDD VSS VSS gf180mcu_fd_sc_mcu7t5v0__inv_1
XFILLER_39_341 VDD VDD VSS VSS gf180mcu_fd_sc_mcu7t5v0__fillcap_8
XFILLER_39_352 VDD VDD VSS VSS gf180mcu_fd_sc_mcu7t5v0__fillcap_64
XFILLER_54_311 VDD VDD VSS VSS gf180mcu_fd_sc_mcu7t5v0__fillcap_4
Xu_core.delay_paths.u_trc1.gen_inv_stage\[52\].inv u_core.delay_paths.u_trc1.gen_inv_stage\[52\].inv/I
+ u_core.delay_paths.u_trc1.gen_inv_stage\[53\].inv/I VDD VDD VSS VSS gf180mcu_fd_sc_mcu7t5v0__inv_1
Xu_core.delay_paths.u_trc3.gen_inv_stage\[4\].inv u_core.delay_paths.u_trc3.gen_inv_stage\[4\].inv/I
+ u_core.delay_paths.u_trc3.gen_inv_stage\[5\].inv/I VDD VDD VSS VSS gf180mcu_fd_sc_mcu7t5v0__inv_1
XTAP_TAPCELL_ROW_1_134 VDD VSS gf180mcu_fd_sc_mcu7t5v0__filltie
Xu_core.delay_paths.u_trc1.gen_inv_stage\[67\].inv u_core.delay_paths.u_trc1.gen_inv_stage\[67\].inv/I
+ u_core.delay_paths.u_trc1.gen_inv_stage\[68\].inv/I VDD VDD VSS VSS gf180mcu_fd_sc_mcu7t5v0__inv_1
Xfanout34 _666_/RN _702_/RN VDD VDD VSS VSS gf180mcu_fd_sc_mcu7t5v0__dlyb_1
Xfanout23 _615_/CLK _626_/CLK VDD VDD VSS VSS gf180mcu_fd_sc_mcu7t5v0__dlyb_1
XFILLER_13_66 VDD VDD VSS VSS gf180mcu_fd_sc_mcu7t5v0__fillcap_4
XFILLER_13_99 VDD VDD VSS VSS gf180mcu_fd_sc_mcu7t5v0__fillcap_8
XFILLER_1_189 VDD VDD VSS VSS gf180mcu_fd_sc_mcu7t5v0__fill_1
XFILLER_49_138 VDD VDD VSS VSS gf180mcu_fd_sc_mcu7t5v0__fill_2
X_514_ _514_/A1 _509_/S _514_/B _685_/D VDD VDD VSS VSS gf180mcu_fd_sc_mcu7t5v0__oai21_1
X_445_ _636_/Q _437_/Z _448_/B1 _647_/Q _453_/B _446_/B2 VDD VDD VSS VSS gf180mcu_fd_sc_mcu7t5v0__aoi221_1
X_376_ _677_/Q _673_/Q _378_/B VDD VDD VSS VSS gf180mcu_fd_sc_mcu7t5v0__and2_1
XFILLER_9_212 VDD VDD VSS VSS gf180mcu_fd_sc_mcu7t5v0__fillcap_4
Xclkload9 _688_/CLK clkload9/Z VDD VDD VSS VSS gf180mcu_fd_sc_mcu7t5v0__clkbuf_2
Xclkbuf_4_10__f_iCLK clkbuf_0_iCLK/Z _695_/CLK VDD VDD VSS VSS gf180mcu_fd_sc_mcu7t5v0__clkbuf_16
XTAP_TAPCELL_ROW_37_350 VDD VSS gf180mcu_fd_sc_mcu7t5v0__filltie
XTAP_TAPCELL_ROW_29_306 VDD VSS gf180mcu_fd_sc_mcu7t5v0__filltie
XFILLER_10_244 VDD VDD VSS VSS gf180mcu_fd_sc_mcu7t5v0__fill_1
XFILLER_6_215 VDD VDD VSS VSS gf180mcu_fd_sc_mcu7t5v0__fillcap_8
XTAP_TAPCELL_ROW_20_250 VDD VSS gf180mcu_fd_sc_mcu7t5v0__filltie
XFILLER_40_53 VDD VDD VSS VSS gf180mcu_fd_sc_mcu7t5v0__fillcap_8
XFILLER_6_237 VDD VDD VSS VSS gf180mcu_fd_sc_mcu7t5v0__fillcap_8
Xu_core.delay_paths.u_trc0.gen_inv_stage\[140\].inv u_core.delay_paths.u_trc0.gen_inv_stage\[140\].inv/I
+ u_core.delay_paths.u_trc0.gen_inv_stage\[141\].inv/I VDD VDD VSS VSS gf180mcu_fd_sc_mcu7t5v0__inv_1
Xu_core.delay_paths.u_trc0.gen_inv_stage\[155\].inv u_core.delay_paths.u_trc0.gen_inv_stage\[155\].inv/I
+ u_core.delay_paths.u_trc0.gen_inv_stage\[156\].inv/I VDD VDD VSS VSS gf180mcu_fd_sc_mcu7t5v0__inv_2
XFILLER_33_347 VDD VDD VSS VSS gf180mcu_fd_sc_mcu7t5v0__fill_2
XFILLER_45_196 VDD VDD VSS VSS gf180mcu_fd_sc_mcu7t5v0__fillcap_4
X_428_ _639_/Q _428_/A2 _428_/B _696_/Q _429_/A2 VDD VDD VSS VSS gf180mcu_fd_sc_mcu7t5v0__aoi211_1
Xu_core.delay_paths.u_trc0.gen_inv_stage\[108\].inv u_core.delay_paths.u_trc0.gen_inv_stage\[108\].inv/I
+ u_core.delay_paths.u_trc0.gen_inv_stage\[109\].inv/I VDD VDD VSS VSS gf180mcu_fd_sc_mcu7t5v0__inv_2
X_359_ _624_/Q _623_/Q _624_/D VDD VDD VSS VSS gf180mcu_fd_sc_mcu7t5v0__xor2_1
XTAP_TAPCELL_ROW_43_386 VDD VSS gf180mcu_fd_sc_mcu7t5v0__filltie
XFILLER_46_2 VDD VDD VSS VSS gf180mcu_fd_sc_mcu7t5v0__fillcap_32
XFILLER_5_292 VDD VDD VSS VSS gf180mcu_fd_sc_mcu7t5v0__fill_1
Xu_core.delay_paths.u_trc0.gen_inv_stage\[91\].inv u_core.delay_paths.u_trc0.gen_inv_stage\[91\].inv/I
+ u_core.delay_paths.u_trc0.gen_inv_stage\[92\].inv/I VDD VDD VSS VSS gf180mcu_fd_sc_mcu7t5v0__inv_1
XFILLER_24_314 VDD VDD VSS VSS gf180mcu_fd_sc_mcu7t5v0__fill_1
Xinput2 iSPI_CS input2/Z VDD VDD VSS VSS gf180mcu_fd_sc_mcu7t5v0__dlyb_1
Xu_core.delay_paths.u_trc0.gen_inv_stage\[44\].inv u_core.delay_paths.u_trc0.gen_inv_stage\[44\].inv/I
+ u_core.delay_paths.u_trc0.gen_inv_stage\[45\].inv/I VDD VDD VSS VSS gf180mcu_fd_sc_mcu7t5v0__inv_1
XFILLER_10_34 VDD VDD VSS VSS gf180mcu_fd_sc_mcu7t5v0__fill_1
Xu_core.delay_paths.u_trc0.gen_inv_stage\[59\].inv u_core.delay_paths.u_trc0.gen_inv_stage\[59\].inv/I
+ u_core.delay_paths.u_trc0.gen_inv_stage\[60\].inv/I VDD VDD VSS VSS gf180mcu_fd_sc_mcu7t5v0__inv_1
XFILLER_42_177 VDD VDD VSS VSS gf180mcu_fd_sc_mcu7t5v0__fill_2
XPHY_EDGE_ROW_2_Left_63 VDD VSS gf180mcu_fd_sc_mcu7t5v0__endcap
XFILLER_2_295 VDD VDD VSS VSS gf180mcu_fd_sc_mcu7t5v0__fillcap_8
XFILLER_21_317 VDD VDD VSS VSS gf180mcu_fd_sc_mcu7t5v0__fillcap_16
XFILLER_56_247 VDD VDD VSS VSS gf180mcu_fd_sc_mcu7t5v0__fillcap_64
XFILLER_12_317 VDD VDD VSS VSS gf180mcu_fd_sc_mcu7t5v0__fill_2
XFILLER_24_177 VDD VDD VSS VSS gf180mcu_fd_sc_mcu7t5v0__fill_2
XFILLER_21_66 VDD VDD VSS VSS gf180mcu_fd_sc_mcu7t5v0__fillcap_4
XFILLER_21_88 VDD VDD VSS VSS gf180mcu_fd_sc_mcu7t5v0__fill_1
X_693_ _693_/D _693_/RN _693_/CLK _693_/Q VDD VDD VSS VSS gf180mcu_fd_sc_mcu7t5v0__dffrnq_1
XFILLER_7_343 VDD VDD VSS VSS gf180mcu_fd_sc_mcu7t5v0__fillcap_4
XFILLER_38_225 VDD VDD VSS VSS gf180mcu_fd_sc_mcu7t5v0__fillcap_8
XFILLER_53_206 VDD VDD VSS VSS gf180mcu_fd_sc_mcu7t5v0__fillcap_4
Xu_core.delay_paths.u_trc3.gen_inv_stage\[20\].inv u_core.delay_paths.u_trc3.gen_inv_stage\[20\].inv/I
+ u_core.delay_paths.u_trc3.gen_inv_stage\[21\].inv/I VDD VDD VSS VSS gf180mcu_fd_sc_mcu7t5v0__inv_1
Xu_core.delay_paths.u_trc3.gen_inv_stage\[35\].inv u_core.delay_paths.u_trc3.gen_inv_stage\[35\].inv/I
+ u_core.delay_paths.u_trc3.gen_inv_stage\[36\].inv/I VDD VDD VSS VSS gf180mcu_fd_sc_mcu7t5v0__inv_1
XFILLER_12_103 VDD VDD VSS VSS gf180mcu_fd_sc_mcu7t5v0__fill_2
XFILLER_12_169 VDD VDD VSS VSS gf180mcu_fd_sc_mcu7t5v0__fill_2
XFILLER_8_107 VDD VDD VSS VSS gf180mcu_fd_sc_mcu7t5v0__fillcap_8
XTAP_TAPCELL_ROW_7_173 VDD VSS gf180mcu_fd_sc_mcu7t5v0__filltie
X_676_ _676_/D _677_/RN _685_/CLK _676_/Q VDD VDD VSS VSS gf180mcu_fd_sc_mcu7t5v0__dffrnq_1
XFILLER_11_191 VDD VDD VSS VSS gf180mcu_fd_sc_mcu7t5v0__fill_2
X_530_ _612_/D _640_/Q _534_/S _640_/D VDD VDD VSS VSS gf180mcu_fd_sc_mcu7t5v0__mux2_2
X_461_ _461_/A1 _607_/Q _461_/B hold64/I VDD VDD VSS VSS gf180mcu_fd_sc_mcu7t5v0__oai21_1
XTAP_TAPCELL_ROW_4_154 VDD VSS gf180mcu_fd_sc_mcu7t5v0__filltie
XFILLER_40_231 VDD VDD VSS VSS gf180mcu_fd_sc_mcu7t5v0__fill_2
X_392_ _395_/A2 wire17/Z _400_/B VDD VDD VSS VSS gf180mcu_fd_sc_mcu7t5v0__nand2_1
XFILLER_4_165 VDD VDD VSS VSS gf180mcu_fd_sc_mcu7t5v0__fillcap_8
XFILLER_4_58 VDD VDD VSS VSS gf180mcu_fd_sc_mcu7t5v0__fill_1
XTAP_TAPCELL_ROW_10_189 VDD VSS gf180mcu_fd_sc_mcu7t5v0__filltie
XPHY_EDGE_ROW_31_Left_92 VDD VSS gf180mcu_fd_sc_mcu7t5v0__endcap
XFILLER_16_283 VDD VDD VSS VSS gf180mcu_fd_sc_mcu7t5v0__fill_1
XFILLER_23_209 VDD VDD VSS VSS gf180mcu_fd_sc_mcu7t5v0__fill_1
XFILLER_31_220 VDD VDD VSS VSS gf180mcu_fd_sc_mcu7t5v0__fill_2
X_659_ _659_/D _661_/RN _703_/CLK _659_/Q VDD VDD VSS VSS gf180mcu_fd_sc_mcu7t5v0__dffrnq_1
Xu_core.delay_paths.u_trc2.gen_inv_stage\[74\].inv u_core.delay_paths.u_trc2.gen_inv_stage\[74\].inv/I
+ u_core.delay_paths.u_trc2.gen_inv_stage\[75\].inv/I VDD VDD VSS VSS gf180mcu_fd_sc_mcu7t5v0__inv_1
Xu_core.delay_paths.u_trc2.gen_inv_stage\[89\].inv u_core.delay_paths.u_trc2.gen_inv_stage\[89\].inv/I
+ u_core.delay_paths.u_trc2.gen_inv_stage\[90\].inv/I VDD VDD VSS VSS gf180mcu_fd_sc_mcu7t5v0__inv_1
Xu_core.delay_paths.u_trc2.gen_inv_stage\[12\].inv u_core.delay_paths.u_trc2.gen_inv_stage\[12\].inv/I
+ u_core.delay_paths.u_trc2.gen_inv_stage\[13\].inv/I VDD VDD VSS VSS gf180mcu_fd_sc_mcu7t5v0__inv_1
XTAP_TAPCELL_ROW_1_135 VDD VSS gf180mcu_fd_sc_mcu7t5v0__filltie
Xu_core.delay_paths.u_trc2.gen_inv_stage\[27\].inv u_core.delay_paths.u_trc2.gen_inv_stage\[27\].inv/I
+ u_core.delay_paths.u_trc2.gen_inv_stage\[28\].inv/I VDD VDD VSS VSS gf180mcu_fd_sc_mcu7t5v0__inv_1
Xfanout35 _691_/RN _642_/RN VDD VDD VSS VSS gf180mcu_fd_sc_mcu7t5v0__dlyb_1
Xfanout24 input4/Z _615_/CLK VDD VDD VSS VSS gf180mcu_fd_sc_mcu7t5v0__buf_1
XFILLER_1_102 VDD VDD VSS VSS gf180mcu_fd_sc_mcu7t5v0__fill_1
X_513_ _681_/Q _509_/S _514_/B VDD VDD VSS VSS gf180mcu_fd_sc_mcu7t5v0__nand2_1
X_444_ _688_/Q _447_/A2 _446_/B1 VDD VDD VSS VSS gf180mcu_fd_sc_mcu7t5v0__nand2_1
XFILLER_13_286 VDD VDD VSS VSS gf180mcu_fd_sc_mcu7t5v0__fillcap_16
X_375_ _683_/Q _373_/Z _374_/Z _420_/A1 VDD VDD VSS VSS gf180mcu_fd_sc_mcu7t5v0__nand3_1
XTAP_TAPCELL_ROW_23_270 VDD VSS gf180mcu_fd_sc_mcu7t5v0__filltie
XFILLER_9_279 VDD VDD VSS VSS gf180mcu_fd_sc_mcu7t5v0__fill_1
Xu_core.delay_paths.u_trc1.gen_inv_stage\[114\].inv u_core.delay_paths.u_trc1.gen_inv_stage\[114\].inv/I
+ u_core.delay_paths.u_trc1.gen_inv_stage\[115\].inv/I VDD VDD VSS VSS gf180mcu_fd_sc_mcu7t5v0__inv_1
Xu_core.delay_paths.u_trc1.gen_inv_stage\[129\].inv u_core.delay_paths.u_trc1.gen_inv_stage\[129\].inv/I
+ u_core.delay_paths.u_trc1.gen_inv_stage\[130\].inv/I VDD VDD VSS VSS gf180mcu_fd_sc_mcu7t5v0__inv_1
XTAP_TAPCELL_ROW_29_307 VDD VSS gf180mcu_fd_sc_mcu7t5v0__filltie
XFILLER_27_356 VDD VDD VSS VSS gf180mcu_fd_sc_mcu7t5v0__fill_2
XTAP_TAPCELL_ROW_37_351 VDD VSS gf180mcu_fd_sc_mcu7t5v0__filltie
XFILLER_10_212 VDD VDD VSS VSS gf180mcu_fd_sc_mcu7t5v0__fillcap_4
XFILLER_50_381 VDD VDD VSS VSS gf180mcu_fd_sc_mcu7t5v0__fillcap_4
XTAP_TAPCELL_ROW_20_251 VDD VSS gf180mcu_fd_sc_mcu7t5v0__filltie
XFILLER_6_2 VDD VDD VSS VSS gf180mcu_fd_sc_mcu7t5v0__fillcap_32
Xu_core.delay_paths.u_trc1.gen_inv_stage\[4\].inv u_core.delay_paths.u_trc1.gen_inv_stage\[4\].inv/I
+ u_core.delay_paths.u_trc1.gen_inv_stage\[5\].inv/I VDD VDD VSS VSS gf180mcu_fd_sc_mcu7t5v0__inv_1
XFILLER_1_48 VDD VDD VSS VSS gf180mcu_fd_sc_mcu7t5v0__fill_2
XFILLER_45_142 VDD VDD VSS VSS gf180mcu_fd_sc_mcu7t5v0__fillcap_16
XFILLER_18_389 VDD VDD VSS VSS gf180mcu_fd_sc_mcu7t5v0__fill_1
XFILLER_45_164 VDD VDD VSS VSS gf180mcu_fd_sc_mcu7t5v0__fillcap_32
X_427_ _700_/Q _696_/Q _464_/A2 VDD VDD VSS VSS gf180mcu_fd_sc_mcu7t5v0__nor2_1
X_358_ _725_/I _724_/I _609_/D VDD VDD VSS VSS gf180mcu_fd_sc_mcu7t5v0__xor2_1
XTAP_TAPCELL_ROW_43_387 VDD VSS gf180mcu_fd_sc_mcu7t5v0__filltie
XFILLER_5_282 VDD VDD VSS VSS gf180mcu_fd_sc_mcu7t5v0__fillcap_4
Xu_core.delay_paths.u_trc1.gen_inv_stage\[51\].inv u_core.delay_paths.u_trc1.gen_inv_stage\[51\].inv/I
+ u_core.delay_paths.u_trc1.gen_inv_stage\[52\].inv/I VDD VDD VSS VSS gf180mcu_fd_sc_mcu7t5v0__inv_1
Xu_core.delay_paths.u_trc3.gen_inv_stage\[3\].inv u_core.delay_paths.u_trc3.gen_inv_stage\[3\].inv/I
+ u_core.delay_paths.u_trc3.gen_inv_stage\[4\].inv/I VDD VDD VSS VSS gf180mcu_fd_sc_mcu7t5v0__inv_1
XFILLER_39_2 VDD VDD VSS VSS gf180mcu_fd_sc_mcu7t5v0__fillcap_16
XFILLER_56_429 VDD VDD VSS VSS gf180mcu_fd_sc_mcu7t5v0__fill_1
Xu_core.delay_paths.u_trc1.gen_inv_stage\[66\].inv u_core.delay_paths.u_trc1.gen_inv_stage\[66\].inv/I
+ u_core.delay_paths.u_trc1.gen_inv_stage\[67\].inv/I VDD VDD VSS VSS gf180mcu_fd_sc_mcu7t5v0__inv_1
XPHY_EDGE_ROW_18_Right_18 VDD VSS gf180mcu_fd_sc_mcu7t5v0__endcap
Xinput3 iSPI_MOSI _611_/D VDD VDD VSS VSS gf180mcu_fd_sc_mcu7t5v0__dlyb_1
XTAP_TAPCELL_ROW_34_332 VDD VSS gf180mcu_fd_sc_mcu7t5v0__filltie
XPHY_EDGE_ROW_27_Right_27 VDD VSS gf180mcu_fd_sc_mcu7t5v0__endcap
XFILLER_3_208 VDD VDD VSS VSS gf180mcu_fd_sc_mcu7t5v0__fill_2
XFILLER_59_212 VDD VDD VSS VSS gf180mcu_fd_sc_mcu7t5v0__fillcap_64
Xu_core.delay_paths.u_trc1.gen_inv_stage\[19\].inv u_core.delay_paths.u_trc1.gen_inv_stage\[19\].inv/I
+ u_core.delay_paths.u_trc1.gen_inv_stage\[20\].inv/I VDD VDD VSS VSS gf180mcu_fd_sc_mcu7t5v0__inv_1
XPHY_EDGE_ROW_36_Right_36 VDD VSS gf180mcu_fd_sc_mcu7t5v0__endcap
XFILLER_19_109 VDD VDD VSS VSS gf180mcu_fd_sc_mcu7t5v0__fill_1
XFILLER_19_66 VDD VDD VSS VSS gf180mcu_fd_sc_mcu7t5v0__fillcap_4
XFILLER_19_88 VDD VDD VSS VSS gf180mcu_fd_sc_mcu7t5v0__fillcap_8
XFILLER_27_142 VDD VDD VSS VSS gf180mcu_fd_sc_mcu7t5v0__fillcap_4
Xclkbuf_4_8__f_iCLK clkbuf_0_iCLK/Z _644_/CLK VDD VDD VSS VSS gf180mcu_fd_sc_mcu7t5v0__clkbuf_16
XPHY_EDGE_ROW_45_Right_45 VDD VSS gf180mcu_fd_sc_mcu7t5v0__endcap
XTAP_TAPCELL_ROW_40_368 VDD VSS gf180mcu_fd_sc_mcu7t5v0__filltie
XPHY_EDGE_ROW_54_Right_54 VDD VSS gf180mcu_fd_sc_mcu7t5v0__endcap
XFILLER_38_429 VDD VDD VSS VSS gf180mcu_fd_sc_mcu7t5v0__fill_1
XFILLER_21_307 VDD VDD VSS VSS gf180mcu_fd_sc_mcu7t5v0__fill_1
Xu_core.delay_paths.u_trc0.gen_inv_stage\[154\].inv u_core.delay_paths.u_trc0.gen_inv_stage\[154\].inv/I
+ u_core.delay_paths.u_trc0.gen_inv_stage\[155\].inv/I VDD VDD VSS VSS gf180mcu_fd_sc_mcu7t5v0__inv_2
XFILLER_20_384 VDD VDD VSS VSS gf180mcu_fd_sc_mcu7t5v0__fill_1
Xu_core.delay_paths.u_trc0.gen_inv_stage\[169\].inv u_core.delay_paths.u_trc0.gen_inv_stage\[169\].inv/I
+ u_core.delay_paths.u_trc0.gen_inv_stage\[170\].inv/I VDD VDD VSS VSS gf180mcu_fd_sc_mcu7t5v0__inv_1
XFILLER_46_53 VDD VDD VSS VSS gf180mcu_fd_sc_mcu7t5v0__fill_2
Xu_core.delay_paths.u_trc0.gen_inv_stage\[107\].inv u_core.delay_paths.u_trc0.gen_inv_stage\[107\].inv/I
+ u_core.delay_paths.u_trc0.gen_inv_stage\[108\].inv/I VDD VDD VSS VSS gf180mcu_fd_sc_mcu7t5v0__inv_2
Xmax_cap10 _527_/A2 _528_/S VDD VDD VSS VSS gf180mcu_fd_sc_mcu7t5v0__buf_2
X_692_ _692_/D _693_/RN _692_/CLK _692_/Q VDD VDD VSS VSS gf180mcu_fd_sc_mcu7t5v0__dffrnq_1
XFILLER_30_104 VDD VDD VSS VSS gf180mcu_fd_sc_mcu7t5v0__fill_1
XFILLER_30_115 VDD VDD VSS VSS gf180mcu_fd_sc_mcu7t5v0__fill_2
Xu_core.delay_paths.u_trc0.gen_inv_stage\[90\].inv u_core.delay_paths.u_trc0.gen_inv_stage\[90\].inv/I
+ u_core.delay_paths.u_trc0.gen_inv_stage\[91\].inv/I VDD VDD VSS VSS gf180mcu_fd_sc_mcu7t5v0__inv_1
XFILLER_38_237 VDD VDD VSS VSS gf180mcu_fd_sc_mcu7t5v0__fill_2
Xu_core.delay_paths.u_trc0.gen_inv_stage\[43\].inv u_core.delay_paths.u_trc0.gen_inv_stage\[43\].inv/I
+ u_core.delay_paths.u_trc0.gen_inv_stage\[44\].inv/I VDD VDD VSS VSS gf180mcu_fd_sc_mcu7t5v0__inv_1
XFILLER_21_115 VDD VDD VSS VSS gf180mcu_fd_sc_mcu7t5v0__fillcap_16
Xu_core.delay_paths.u_trc0.gen_inv_stage\[58\].inv u_core.delay_paths.u_trc0.gen_inv_stage\[58\].inv/I
+ u_core.delay_paths.u_trc0.gen_inv_stage\[59\].inv/I VDD VDD VSS VSS gf180mcu_fd_sc_mcu7t5v0__inv_1
XFILLER_16_34 VDD VDD VSS VSS gf180mcu_fd_sc_mcu7t5v0__fill_1
XFILLER_12_148 VDD VDD VSS VSS gf180mcu_fd_sc_mcu7t5v0__fill_1
XFILLER_8_119 VDD VDD VSS VSS gf180mcu_fd_sc_mcu7t5v0__fill_1
XTAP_TAPCELL_ROW_50_430 VDD VSS gf180mcu_fd_sc_mcu7t5v0__filltie
XPHY_EDGE_ROW_0_Right_0 VDD VSS gf180mcu_fd_sc_mcu7t5v0__endcap
XFILLER_4_303 VDD VDD VSS VSS gf180mcu_fd_sc_mcu7t5v0__fillcap_8
XTAP_TAPCELL_ROW_7_174 VDD VSS gf180mcu_fd_sc_mcu7t5v0__filltie
XFILLER_28_281 VDD VDD VSS VSS gf180mcu_fd_sc_mcu7t5v0__fillcap_16
XFILLER_31_413 VDD VDD VSS VSS gf180mcu_fd_sc_mcu7t5v0__fillcap_4
XFILLER_43_273 VDD VDD VSS VSS gf180mcu_fd_sc_mcu7t5v0__fill_2
X_675_ _675_/D _675_/RN _699_/CLK _675_/Q VDD VDD VSS VSS gf180mcu_fd_sc_mcu7t5v0__dffrnq_1
XFILLER_7_174 VDD VDD VSS VSS gf180mcu_fd_sc_mcu7t5v0__fillcap_16
XPHY_EDGE_ROW_44_Left_105 VDD VSS gf180mcu_fd_sc_mcu7t5v0__endcap
XFILLER_21_2 VDD VDD VSS VSS gf180mcu_fd_sc_mcu7t5v0__fillcap_64
XPHY_EDGE_ROW_53_Left_114 VDD VSS gf180mcu_fd_sc_mcu7t5v0__endcap
XTAP_TAPCELL_ROW_4_155 VDD VSS gf180mcu_fd_sc_mcu7t5v0__filltie
XFILLER_27_66 VDD VDD VSS VSS gf180mcu_fd_sc_mcu7t5v0__fillcap_4
X_460_ _603_/Q _605_/Q _705_/D _703_/D VDD VDD VSS VSS gf180mcu_fd_sc_mcu7t5v0__or3_1
X_391_ _395_/A2 wire17/Z _399_/B VDD VDD VSS VSS gf180mcu_fd_sc_mcu7t5v0__and2_1
XFILLER_4_177 VDD VDD VSS VSS gf180mcu_fd_sc_mcu7t5v0__fillcap_16
XFILLER_4_37 VDD VDD VSS VSS gf180mcu_fd_sc_mcu7t5v0__fill_2
XFILLER_48_387 VDD VDD VSS VSS gf180mcu_fd_sc_mcu7t5v0__fillcap_32
X_658_ _658_/D _661_/RN _703_/CLK _658_/Q VDD VDD VSS VSS gf180mcu_fd_sc_mcu7t5v0__dffrnq_1
X_589_ _601_/I _616_/RN VDD VDD VSS VSS gf180mcu_fd_sc_mcu7t5v0__clkinv_1
Xu_core.delay_paths.u_trc3.gen_inv_stage\[34\].inv u_core.delay_paths.u_trc3.gen_inv_stage\[34\].inv/I
+ u_core.delay_paths.u_trc3.gen_inv_stage\[35\].inv/I VDD VDD VSS VSS gf180mcu_fd_sc_mcu7t5v0__inv_1
XFILLER_58_107 VDD VDD VSS VSS gf180mcu_fd_sc_mcu7t5v0__fillcap_64
XTAP_TAPCELL_ROW_1_136 VDD VSS gf180mcu_fd_sc_mcu7t5v0__filltie
Xfanout25 _602_/I _601_/I VDD VDD VSS VSS gf180mcu_fd_sc_mcu7t5v0__dlyb_1
XFILLER_49_118 VDD VDD VSS VSS gf180mcu_fd_sc_mcu7t5v0__fillcap_16
X_512_ _512_/A1 _702_/D _512_/B _684_/D VDD VDD VSS VSS gf180mcu_fd_sc_mcu7t5v0__oai21_1
X_443_ _443_/A1 _453_/B _443_/B1 _443_/B2 _628_/D VDD VDD VSS VSS gf180mcu_fd_sc_mcu7t5v0__aoi22_1
X_374_ _684_/Q _374_/A2 _368_/Z _374_/Z VDD VDD VSS VSS gf180mcu_fd_sc_mcu7t5v0__xor3_1
XTAP_TAPCELL_ROW_23_271 VDD VSS gf180mcu_fd_sc_mcu7t5v0__filltie
XFILLER_9_269 VDD VDD VSS VSS gf180mcu_fd_sc_mcu7t5v0__fillcap_8
XFILLER_39_184 VDD VDD VSS VSS gf180mcu_fd_sc_mcu7t5v0__fill_2
XFILLER_39_195 VDD VDD VSS VSS gf180mcu_fd_sc_mcu7t5v0__fillcap_8
XFILLER_59_416 VDD VDD VSS VSS gf180mcu_fd_sc_mcu7t5v0__fillcap_4
XFILLER_24_34 VDD VDD VSS VSS gf180mcu_fd_sc_mcu7t5v0__fill_1
XFILLER_42_305 VDD VDD VSS VSS gf180mcu_fd_sc_mcu7t5v0__fill_1
XTAP_TAPCELL_ROW_37_352 VDD VSS gf180mcu_fd_sc_mcu7t5v0__filltie
XFILLER_10_224 VDD VDD VSS VSS gf180mcu_fd_sc_mcu7t5v0__fillcap_8
XTAP_TAPCELL_ROW_20_252 VDD VSS gf180mcu_fd_sc_mcu7t5v0__filltie
XFILLER_2_423 VDD VDD VSS VSS gf180mcu_fd_sc_mcu7t5v0__fillcap_4
XFILLER_40_99 VDD VDD VSS VSS gf180mcu_fd_sc_mcu7t5v0__fillcap_4
Xclkbuf_4_4__f_iCLK clkbuf_0_iCLK/Z _682_/CLK VDD VDD VSS VSS gf180mcu_fd_sc_mcu7t5v0__clkbuf_16
XFILLER_18_313 VDD VDD VSS VSS gf180mcu_fd_sc_mcu7t5v0__fill_2
Xu_core.delay_paths.u_trc2.gen_inv_stage\[73\].inv u_core.delay_paths.u_trc2.gen_inv_stage\[73\].inv/I
+ u_core.delay_paths.u_trc2.gen_inv_stage\[74\].inv/I VDD VDD VSS VSS gf180mcu_fd_sc_mcu7t5v0__inv_1
XFILLER_33_349 VDD VDD VSS VSS gf180mcu_fd_sc_mcu7t5v0__fill_1
Xu_core.delay_paths.u_trc2.gen_inv_stage\[88\].inv u_core.delay_paths.u_trc2.gen_inv_stage\[88\].inv/I
+ u_core.delay_paths.u_trc2.gen_inv_stage\[89\].inv/I VDD VDD VSS VSS gf180mcu_fd_sc_mcu7t5v0__inv_1
X_426_ _534_/S _622_/D VDD VDD VSS VSS gf180mcu_fd_sc_mcu7t5v0__clkinv_1
X_357_ _723_/I _722_/I _607_/D VDD VDD VSS VSS gf180mcu_fd_sc_mcu7t5v0__xor2_1
XTAP_TAPCELL_ROW_43_388 VDD VSS gf180mcu_fd_sc_mcu7t5v0__filltie
XFILLER_60_6 VDD VDD VSS VSS gf180mcu_fd_sc_mcu7t5v0__fill_2
Xu_core.delay_paths.u_trc2.gen_inv_stage\[11\].inv u_core.delay_paths.u_trc2.gen_inv_stage\[11\].inv/I
+ u_core.delay_paths.u_trc2.gen_inv_stage\[12\].inv/I VDD VDD VSS VSS gf180mcu_fd_sc_mcu7t5v0__inv_1
XFILLER_56_419 VDD VDD VSS VSS gf180mcu_fd_sc_mcu7t5v0__fillcap_8
Xu_core.delay_paths.u_trc2.gen_inv_stage\[26\].inv u_core.delay_paths.u_trc2.gen_inv_stage\[26\].inv/I
+ u_core.delay_paths.u_trc2.gen_inv_stage\[27\].inv/I VDD VDD VSS VSS gf180mcu_fd_sc_mcu7t5v0__inv_1
Xinput4 iSPI_SCK input4/Z VDD VDD VSS VSS gf180mcu_fd_sc_mcu7t5v0__dlyb_1
XTAP_TAPCELL_ROW_34_333 VDD VSS gf180mcu_fd_sc_mcu7t5v0__filltie
XFILLER_10_69 VDD VDD VSS VSS gf180mcu_fd_sc_mcu7t5v0__fillcap_8
XFILLER_27_154 VDD VDD VSS VSS gf180mcu_fd_sc_mcu7t5v0__fill_2
XFILLER_27_165 VDD VDD VSS VSS gf180mcu_fd_sc_mcu7t5v0__fillcap_8
XFILLER_23_360 VDD VDD VSS VSS gf180mcu_fd_sc_mcu7t5v0__fill_2
XFILLER_42_168 VDD VDD VSS VSS gf180mcu_fd_sc_mcu7t5v0__fill_2
XTAP_TAPCELL_ROW_40_369 VDD VSS gf180mcu_fd_sc_mcu7t5v0__filltie
XFILLER_38_419 VDD VDD VSS VSS gf180mcu_fd_sc_mcu7t5v0__fillcap_8
Xu_core.delay_paths.u_trc1.gen_inv_stage\[113\].inv u_core.delay_paths.u_trc1.gen_inv_stage\[113\].inv/I
+ u_core.delay_paths.u_trc1.gen_inv_stage\[114\].inv/I VDD VDD VSS VSS gf180mcu_fd_sc_mcu7t5v0__inv_1
Xu_core.delay_paths.u_trc1.gen_inv_stage\[128\].inv u_core.delay_paths.u_trc1.gen_inv_stage\[128\].inv/I
+ u_core.delay_paths.u_trc1.gen_inv_stage\[129\].inv/I VDD VDD VSS VSS gf180mcu_fd_sc_mcu7t5v0__inv_1
XFILLER_18_165 VDD VDD VSS VSS gf180mcu_fd_sc_mcu7t5v0__fill_2
X_409_ _665_/Q _409_/A2 _428_/A2 VDD VDD VSS VSS gf180mcu_fd_sc_mcu7t5v0__nand2_1
XTAP_TAPCELL_ROW_31_314 VDD VSS gf180mcu_fd_sc_mcu7t5v0__filltie
XFILLER_51_2 VDD VDD VSS VSS gf180mcu_fd_sc_mcu7t5v0__fillcap_64
XFILLER_2_70 VDD VDD VSS VSS gf180mcu_fd_sc_mcu7t5v0__fillcap_4
Xu_core.delay_paths.u_trc1.gen_inv_stage\[3\].inv u_core.delay_paths.u_trc1.gen_inv_stage\[3\].inv/I
+ u_core.delay_paths.u_trc1.gen_inv_stage\[4\].inv/I VDD VDD VSS VSS gf180mcu_fd_sc_mcu7t5v0__inv_1
XFILLER_43_422 VDD VDD VSS VSS gf180mcu_fd_sc_mcu7t5v0__fillcap_8
XFILLER_55_282 VDD VDD VSS VSS gf180mcu_fd_sc_mcu7t5v0__fillcap_64
Xu_core.delay_paths.u_trc1.gen_inv_stage\[50\].inv u_core.delay_paths.u_trc1.gen_inv_stage\[50\].inv/I
+ u_core.delay_paths.u_trc1.gen_inv_stage\[51\].inv/I VDD VDD VSS VSS gf180mcu_fd_sc_mcu7t5v0__inv_1
Xu_core.delay_paths.u_trc3.gen_inv_stage\[2\].inv u_core.delay_paths.u_trc3.gen_inv_stage\[2\].inv/I
+ u_core.delay_paths.u_trc3.gen_inv_stage\[3\].inv/I VDD VDD VSS VSS gf180mcu_fd_sc_mcu7t5v0__inv_1
X_691_ _691_/D _691_/RN _692_/CLK _691_/Q VDD VDD VSS VSS gf180mcu_fd_sc_mcu7t5v0__dffrnq_1
XTAP_TAPCELL_ROW_53_450 VDD VSS gf180mcu_fd_sc_mcu7t5v0__filltie
Xu_core.delay_paths.u_trc1.gen_inv_stage\[65\].inv u_core.delay_paths.u_trc1.gen_inv_stage\[65\].inv/I
+ u_core.delay_paths.u_trc1.gen_inv_stage\[66\].inv/I VDD VDD VSS VSS gf180mcu_fd_sc_mcu7t5v0__inv_1
XFILLER_14_190 VDD VDD VSS VSS gf180mcu_fd_sc_mcu7t5v0__fillcap_8
XFILLER_21_105 VDD VDD VSS VSS gf180mcu_fd_sc_mcu7t5v0__fill_2
XFILLER_34_411 VDD VDD VSS VSS gf180mcu_fd_sc_mcu7t5v0__fillcap_4
Xu_core.delay_paths.u_trc1.gen_inv_stage\[18\].inv u_core.delay_paths.u_trc1.gen_inv_stage\[18\].inv/I
+ u_core.delay_paths.u_trc1.gen_inv_stage\[19\].inv/I VDD VDD VSS VSS gf180mcu_fd_sc_mcu7t5v0__inv_1
XFILLER_29_216 VDD VDD VSS VSS gf180mcu_fd_sc_mcu7t5v0__fill_2
XFILLER_37_282 VDD VDD VSS VSS gf180mcu_fd_sc_mcu7t5v0__fill_2
XFILLER_52_241 VDD VDD VSS VSS gf180mcu_fd_sc_mcu7t5v0__fillcap_4
XFILLER_32_34 VDD VDD VSS VSS gf180mcu_fd_sc_mcu7t5v0__fill_1
XFILLER_32_89 VDD VDD VSS VSS gf180mcu_fd_sc_mcu7t5v0__fill_1
XTAP_TAPCELL_ROW_50_431 VDD VSS gf180mcu_fd_sc_mcu7t5v0__filltie
X_674_ _674_/D _677_/RN _682_/CLK _674_/Q VDD VDD VSS VSS gf180mcu_fd_sc_mcu7t5v0__dffrnq_1
XTAP_TAPCELL_ROW_7_175 VDD VSS gf180mcu_fd_sc_mcu7t5v0__filltie
XFILLER_7_142 VDD VDD VSS VSS gf180mcu_fd_sc_mcu7t5v0__fillcap_32
Xu_core.delay_paths.u_trc0.gen_inv_stage\[153\].inv u_core.delay_paths.u_trc0.gen_inv_stage\[153\].inv/I
+ u_core.delay_paths.u_trc0.gen_inv_stage\[154\].inv/I VDD VDD VSS VSS gf180mcu_fd_sc_mcu7t5v0__inv_2
XFILLER_14_2 VDD VDD VSS VSS gf180mcu_fd_sc_mcu7t5v0__fillcap_32
Xu_core.delay_paths.u_trc0.gen_inv_stage\[168\].inv u_core.delay_paths.u_trc0.gen_inv_stage\[168\].inv/I
+ u_core.delay_paths.u_trc0.gen_inv_stage\[169\].inv/I VDD VDD VSS VSS gf180mcu_fd_sc_mcu7t5v0__inv_1
XFILLER_34_263 VDD VDD VSS VSS gf180mcu_fd_sc_mcu7t5v0__fillcap_4
Xu_core.delay_paths.u_trc0.gen_inv_stage\[106\].inv u_core.delay_paths.u_trc0.gen_inv_stage\[106\].inv/I
+ u_core.delay_paths.u_trc0.gen_inv_stage\[107\].inv/I VDD VDD VSS VSS gf180mcu_fd_sc_mcu7t5v0__inv_2
XFILLER_17_208 VDD VDD VSS VSS gf180mcu_fd_sc_mcu7t5v0__fill_2
XTAP_TAPCELL_ROW_4_156 VDD VSS gf180mcu_fd_sc_mcu7t5v0__filltie
XFILLER_40_233 VDD VDD VSS VSS gf180mcu_fd_sc_mcu7t5v0__fill_1
X_390_ _681_/Q _377_/Z _390_/Z VDD VDD VSS VSS gf180mcu_fd_sc_mcu7t5v0__xor2_1
XFILLER_43_66 VDD VDD VSS VSS gf180mcu_fd_sc_mcu7t5v0__fillcap_4
XFILLER_43_88 VDD VDD VSS VSS gf180mcu_fd_sc_mcu7t5v0__fillcap_8
Xu_core.delay_paths.u_trc0.gen_inv_stage\[42\].inv u_core.delay_paths.u_trc0.gen_inv_stage\[42\].inv/I
+ u_core.delay_paths.u_trc0.gen_inv_stage\[43\].inv/I VDD VDD VSS VSS gf180mcu_fd_sc_mcu7t5v0__inv_1
XFILLER_48_311 VDD VDD VSS VSS gf180mcu_fd_sc_mcu7t5v0__fillcap_4
Xu_core.delay_paths.u_trc0.gen_inv_stage\[57\].inv u_core.delay_paths.u_trc0.gen_inv_stage\[57\].inv/I
+ u_core.delay_paths.u_trc0.gen_inv_stage\[58\].inv/I VDD VDD VSS VSS gf180mcu_fd_sc_mcu7t5v0__inv_2
X_657_ _657_/D _705_/RN _699_/CLK _657_/Q VDD VDD VSS VSS gf180mcu_fd_sc_mcu7t5v0__dffrnq_1
XTAP_TAPCELL_ROW_18_236 VDD VSS gf180mcu_fd_sc_mcu7t5v0__filltie
XFILLER_31_222 VDD VDD VSS VSS gf180mcu_fd_sc_mcu7t5v0__fill_1
X_588_ _602_/I _615_/RN VDD VDD VSS VSS gf180mcu_fd_sc_mcu7t5v0__clkinv_1
XPHY_EDGE_ROW_18_Left_79 VDD VSS gf180mcu_fd_sc_mcu7t5v0__endcap
Xfanout37 _691_/RN _704_/RN VDD VDD VSS VSS gf180mcu_fd_sc_mcu7t5v0__dlyb_1
Xfanout26 input2/Z _602_/I VDD VDD VSS VSS gf180mcu_fd_sc_mcu7t5v0__dlyb_1
Xfanout15 _435_/Z _453_/B VDD VDD VSS VSS gf180mcu_fd_sc_mcu7t5v0__dlyb_1
XTAP_TAPCELL_ROW_1_137 VDD VSS gf180mcu_fd_sc_mcu7t5v0__filltie
XFILLER_1_115 VDD VDD VSS VSS gf180mcu_fd_sc_mcu7t5v0__fill_1
XFILLER_49_108 VDD VDD VSS VSS gf180mcu_fd_sc_mcu7t5v0__fill_2
X_511_ hold61/Z _702_/D _512_/B VDD VDD VSS VSS gf180mcu_fd_sc_mcu7t5v0__nand2_1
XFILLER_13_200 VDD VDD VSS VSS gf180mcu_fd_sc_mcu7t5v0__fill_1
Xclkbuf_4_0__f_iCLK clkbuf_0_iCLK/Z _700_/CLK VDD VDD VSS VSS gf180mcu_fd_sc_mcu7t5v0__clkbuf_16
X_442_ _635_/Q _437_/Z _535_/A2 _646_/Q _453_/B _443_/B2 VDD VDD VSS VSS gf180mcu_fd_sc_mcu7t5v0__aoi221_1
X_373_ _679_/Q _364_/Z _373_/Z VDD VDD VSS VSS gf180mcu_fd_sc_mcu7t5v0__xor2_1
XFILLER_0_192 VDD VDD VSS VSS gf180mcu_fd_sc_mcu7t5v0__fillcap_8
XFILLER_48_152 VDD VDD VSS VSS gf180mcu_fd_sc_mcu7t5v0__fill_2
XFILLER_27_347 VDD VDD VSS VSS gf180mcu_fd_sc_mcu7t5v0__fill_2
XFILLER_54_177 VDD VDD VSS VSS gf180mcu_fd_sc_mcu7t5v0__fillcap_64
XTAP_TAPCELL_ROW_37_353 VDD VSS gf180mcu_fd_sc_mcu7t5v0__filltie
XFILLER_10_247 VDD VDD VSS VSS gf180mcu_fd_sc_mcu7t5v0__fillcap_16
XFILLER_40_34 VDD VDD VSS VSS gf180mcu_fd_sc_mcu7t5v0__fill_1
XTAP_TAPCELL_ROW_20_253 VDD VSS gf180mcu_fd_sc_mcu7t5v0__filltie
XFILLER_18_325 VDD VDD VSS VSS gf180mcu_fd_sc_mcu7t5v0__fillcap_4
Xu_core.delay_paths.u_trc3.gen_inv_stage\[33\].inv u_core.delay_paths.u_trc3.gen_inv_stage\[33\].inv/I
+ u_core.delay_paths.u_trc3.gen_inv_stage\[34\].inv/I VDD VDD VSS VSS gf180mcu_fd_sc_mcu7t5v0__inv_1
XFILLER_60_158 VDD VDD VSS VSS gf180mcu_fd_sc_mcu7t5v0__fill_2
XFILLER_60_169 VDD VDD VSS VSS gf180mcu_fd_sc_mcu7t5v0__fill_1
X_425_ _620_/Q _425_/A2 _618_/Q _533_/S VDD VDD VSS VSS gf180mcu_fd_sc_mcu7t5v0__nand3_1
X_356_ _721_/I _720_/I _605_/D VDD VDD VSS VSS gf180mcu_fd_sc_mcu7t5v0__xor2_1
XTAP_TAPCELL_ROW_43_389 VDD VSS gf180mcu_fd_sc_mcu7t5v0__filltie
XFILLER_24_306 VDD VDD VSS VSS gf180mcu_fd_sc_mcu7t5v0__fillcap_8
XFILLER_24_317 VDD VDD VSS VSS gf180mcu_fd_sc_mcu7t5v0__fillcap_4
XFILLER_36_177 VDD VDD VSS VSS gf180mcu_fd_sc_mcu7t5v0__fill_2
XFILLER_51_136 VDD VDD VSS VSS gf180mcu_fd_sc_mcu7t5v0__fillcap_4
XTAP_TAPCELL_ROW_34_334 VDD VSS gf180mcu_fd_sc_mcu7t5v0__filltie
XFILLER_10_37 VDD VDD VSS VSS gf180mcu_fd_sc_mcu7t5v0__fillcap_32
XFILLER_35_34 VDD VDD VSS VSS gf180mcu_fd_sc_mcu7t5v0__fill_2
XFILLER_51_66 VDD VDD VSS VSS gf180mcu_fd_sc_mcu7t5v0__fillcap_4
XFILLER_2_243 VDD VDD VSS VSS gf180mcu_fd_sc_mcu7t5v0__fill_2
XFILLER_14_383 VDD VDD VSS VSS gf180mcu_fd_sc_mcu7t5v0__fill_2
XFILLER_18_155 VDD VDD VSS VSS gf180mcu_fd_sc_mcu7t5v0__fillcap_4
XFILLER_18_177 VDD VDD VSS VSS gf180mcu_fd_sc_mcu7t5v0__fill_2
X_408_ _408_/I _409_/A2 VDD VDD VSS VSS gf180mcu_fd_sc_mcu7t5v0__clkinv_1
XTAP_TAPCELL_ROW_31_315 VDD VSS gf180mcu_fd_sc_mcu7t5v0__filltie
X_339_ _527_/A1 _655_/Q _351_/B VDD VDD VSS VSS gf180mcu_fd_sc_mcu7t5v0__nor2_1
XFILLER_44_2 VDD VDD VSS VSS gf180mcu_fd_sc_mcu7t5v0__fillcap_32
XFILLER_24_103 VDD VDD VSS VSS gf180mcu_fd_sc_mcu7t5v0__fill_2
XFILLER_20_331 VDD VDD VSS VSS gf180mcu_fd_sc_mcu7t5v0__fill_1
Xu_core.delay_paths.u_trc2.gen_inv_stage\[72\].inv u_core.delay_paths.u_trc2.gen_inv_stage\[72\].inv/I
+ u_core.delay_paths.u_trc2.gen_inv_stage\[73\].inv/I VDD VDD VSS VSS gf180mcu_fd_sc_mcu7t5v0__inv_1
Xu_core.delay_paths.u_trc2.gen_inv_stage\[87\].inv u_core.delay_paths.u_trc2.gen_inv_stage\[87\].inv/I
+ u_core.delay_paths.u_trc2.gen_inv_stage\[88\].inv/I VDD VDD VSS VSS gf180mcu_fd_sc_mcu7t5v0__inv_1
Xmax_cap12 _577_/A1 _570_/B VDD VDD VSS VSS gf180mcu_fd_sc_mcu7t5v0__clkbuf_1
X_690_ _690_/D _691_/RN _692_/CLK _690_/Q VDD VDD VSS VSS gf180mcu_fd_sc_mcu7t5v0__dffrnq_1
XPHY_EDGE_ROW_6_Left_67 VDD VSS gf180mcu_fd_sc_mcu7t5v0__endcap
XFILLER_15_158 VDD VDD VSS VSS gf180mcu_fd_sc_mcu7t5v0__fill_1
Xu_core.delay_paths.u_trc2.gen_inv_stage\[10\].inv u_core.delay_paths.u_trc2.gen_inv_stage\[9\].inv/ZN
+ u_core.delay_paths.u_trc2.gen_inv_stage\[11\].inv/I VDD VDD VSS VSS gf180mcu_fd_sc_mcu7t5v0__inv_1
XTAP_TAPCELL_ROW_53_451 VDD VSS gf180mcu_fd_sc_mcu7t5v0__filltie
XFILLER_11_386 VDD VDD VSS VSS gf180mcu_fd_sc_mcu7t5v0__fillcap_4
XFILLER_7_335 VDD VDD VSS VSS gf180mcu_fd_sc_mcu7t5v0__fillcap_8
Xu_core.delay_paths.u_trc2.gen_inv_stage\[25\].inv u_core.delay_paths.u_trc2.gen_inv_stage\[25\].inv/I
+ u_core.delay_paths.u_trc2.gen_inv_stage\[26\].inv/I VDD VDD VSS VSS gf180mcu_fd_sc_mcu7t5v0__inv_1
XFILLER_11_80 VDD VDD VSS VSS gf180mcu_fd_sc_mcu7t5v0__fill_2
XFILLER_37_294 VDD VDD VSS VSS gf180mcu_fd_sc_mcu7t5v0__fillcap_4
Xu_core.delay_paths.u_trc1.gen_inv_stage\[112\].inv u_core.delay_paths.u_trc1.gen_inv_stage\[112\].inv/I
+ u_core.delay_paths.u_trc1.gen_inv_stage\[113\].inv/I VDD VDD VSS VSS gf180mcu_fd_sc_mcu7t5v0__inv_1
XFILLER_12_128 VDD VDD VSS VSS gf180mcu_fd_sc_mcu7t5v0__fill_2
Xu_core.delay_paths.u_trc1.gen_inv_stage\[127\].inv u_core.delay_paths.u_trc1.gen_inv_stage\[127\].inv/I
+ u_core.delay_paths.u_trc1.gen_inv_stage\[128\].inv/I VDD VDD VSS VSS gf180mcu_fd_sc_mcu7t5v0__inv_1
XTAP_TAPCELL_ROW_50_432 VDD VSS gf180mcu_fd_sc_mcu7t5v0__filltie
XFILLER_4_349 VDD VDD VSS VSS gf180mcu_fd_sc_mcu7t5v0__fillcap_16
X_673_ _673_/D _677_/RN _682_/CLK _673_/Q VDD VDD VSS VSS gf180mcu_fd_sc_mcu7t5v0__dffrnq_1
XFILLER_11_183 VDD VDD VSS VSS gf180mcu_fd_sc_mcu7t5v0__fillcap_8
Xu_core.delay_paths.u_trc1.gen_inv_stage\[2\].inv u_core.delay_paths.u_trc1.gen_inv_stage\[2\].inv/I
+ u_core.delay_paths.u_trc1.gen_inv_stage\[3\].inv/I VDD VDD VSS VSS gf180mcu_fd_sc_mcu7t5v0__inv_1
XFILLER_19_272 VDD VDD VSS VSS gf180mcu_fd_sc_mcu7t5v0__fillcap_8
Xu_core.delay_paths.u_trc3.gen_inv_stage\[1\].inv u_core.delay_paths.u_trc3.gen_inv_stage\[1\].inv/I
+ u_core.delay_paths.u_trc3.gen_inv_stage\[2\].inv/I VDD VDD VSS VSS gf180mcu_fd_sc_mcu7t5v0__inv_1
Xu_core.delay_paths.u_trc1.gen_inv_stage\[64\].inv u_core.delay_paths.u_trc1.gen_inv_stage\[64\].inv/I
+ u_core.delay_paths.u_trc1.gen_inv_stage\[65\].inv/I VDD VDD VSS VSS gf180mcu_fd_sc_mcu7t5v0__inv_1
XTAP_TAPCELL_ROW_4_157 VDD VSS gf180mcu_fd_sc_mcu7t5v0__filltie
XFILLER_40_267 VDD VDD VSS VSS gf180mcu_fd_sc_mcu7t5v0__fill_1
Xu_core.delay_paths.u_trc1.gen_inv_stage\[79\].inv u_core.delay_paths.u_trc1.gen_inv_stage\[79\].inv/I
+ u_core.delay_paths.u_trc1.gen_inv_stage\[80\].inv/I VDD VDD VSS VSS gf180mcu_fd_sc_mcu7t5v0__inv_1
Xtrc_top oINTERRUPT_CS VDD VDD VSS VSS gf180mcu_fd_sc_mcu7t5v0__tiel
XFILLER_40_289 VDD VDD VSS VSS gf180mcu_fd_sc_mcu7t5v0__fillcap_4
XFILLER_4_39 VDD VDD VSS VSS gf180mcu_fd_sc_mcu7t5v0__fill_1
Xu_core.delay_paths.u_trc1.gen_inv_stage\[17\].inv u_core.delay_paths.u_trc1.gen_inv_stage\[17\].inv/I
+ u_core.delay_paths.u_trc1.gen_inv_stage\[18\].inv/I VDD VDD VSS VSS gf180mcu_fd_sc_mcu7t5v0__inv_1
XFILLER_16_242 VDD VDD VSS VSS gf180mcu_fd_sc_mcu7t5v0__fill_2
X_725_ _725_/I _725_/Z VDD VDD VSS VSS gf180mcu_fd_sc_mcu7t5v0__buf_1
X_656_ _656_/D _699_/RN _699_/CLK _656_/Q VDD VDD VSS VSS gf180mcu_fd_sc_mcu7t5v0__dffrnq_1
X_587_ _602_/I _614_/RN VDD VDD VSS VSS gf180mcu_fd_sc_mcu7t5v0__clkinv_1
XTAP_TAPCELL_ROW_18_237 VDD VSS gf180mcu_fd_sc_mcu7t5v0__filltie
XPHY_EDGE_ROW_9_Left_70 VDD VSS gf180mcu_fd_sc_mcu7t5v0__endcap
XFILLER_31_212 VDD VDD VSS VSS gf180mcu_fd_sc_mcu7t5v0__fillcap_8
XFILLER_3_190 VDD VDD VSS VSS gf180mcu_fd_sc_mcu7t5v0__fillcap_4
XTAP_TAPCELL_ROW_1_138 VDD VSS gf180mcu_fd_sc_mcu7t5v0__filltie
Xfanout38 _691_/RN _619_/RN VDD VDD VSS VSS gf180mcu_fd_sc_mcu7t5v0__dlyb_1
Xfanout27 _666_/RN wire28/I VDD VDD VSS VSS gf180mcu_fd_sc_mcu7t5v0__dlyb_1
XFILLER_1_138 VDD VDD VSS VSS gf180mcu_fd_sc_mcu7t5v0__fill_2
XFILLER_38_34 VDD VDD VSS VSS gf180mcu_fd_sc_mcu7t5v0__fill_1
XFILLER_38_45 VDD VDD VSS VSS gf180mcu_fd_sc_mcu7t5v0__fill_2
XFILLER_45_348 VDD VDD VSS VSS gf180mcu_fd_sc_mcu7t5v0__fill_2
XFILLER_57_142 VDD VDD VSS VSS gf180mcu_fd_sc_mcu7t5v0__fillcap_64
X_510_ hold68/Z _679_/Q _702_/D _683_/D VDD VDD VSS VSS gf180mcu_fd_sc_mcu7t5v0__mux2_2
X_441_ _687_/Q _447_/A2 _443_/B1 VDD VDD VSS VSS gf180mcu_fd_sc_mcu7t5v0__nand2_1
XFILLER_13_212 VDD VDD VSS VSS gf180mcu_fd_sc_mcu7t5v0__fillcap_16
XFILLER_13_278 VDD VDD VSS VSS gf180mcu_fd_sc_mcu7t5v0__fill_2
Xu_core.delay_paths.u_trc0.gen_inv_stage\[152\].inv u_core.delay_paths.u_trc0.gen_inv_stage\[152\].inv/I
+ u_core.delay_paths.u_trc0.gen_inv_stage\[153\].inv/I VDD VDD VSS VSS gf180mcu_fd_sc_mcu7t5v0__inv_2
X_372_ _374_/A2 _368_/Z _397_/A2 VDD VDD VSS VSS gf180mcu_fd_sc_mcu7t5v0__nand2_1
XTAP_TAPCELL_ROW_15_218 VDD VSS gf180mcu_fd_sc_mcu7t5v0__filltie
XPHY_EDGE_ROW_35_Left_96 VDD VSS gf180mcu_fd_sc_mcu7t5v0__endcap
XFILLER_9_205 VDD VDD VSS VSS gf180mcu_fd_sc_mcu7t5v0__fillcap_4
XFILLER_5_422 VDD VDD VSS VSS gf180mcu_fd_sc_mcu7t5v0__fillcap_8
Xu_core.delay_paths.u_trc0.gen_inv_stage\[167\].inv u_core.delay_paths.u_trc0.gen_inv_stage\[167\].inv/I
+ u_core.delay_paths.u_trc0.gen_inv_stage\[168\].inv/I VDD VDD VSS VSS gf180mcu_fd_sc_mcu7t5v0__inv_1
XFILLER_0_160 VDD VDD VSS VSS gf180mcu_fd_sc_mcu7t5v0__fillcap_8
XFILLER_44_381 VDD VDD VSS VSS gf180mcu_fd_sc_mcu7t5v0__fillcap_4
Xu_core.delay_paths.u_trc0.gen_inv_stage\[105\].inv u_core.delay_paths.u_trc0.gen_inv_stage\[105\].inv/I
+ u_core.delay_paths.u_trc0.gen_inv_stage\[106\].inv/I VDD VDD VSS VSS gf180mcu_fd_sc_mcu7t5v0__inv_2
X_639_ _639_/D _704_/RN _704_/CLK _639_/Q VDD VDD VSS VSS gf180mcu_fd_sc_mcu7t5v0__dffsnq_1
XFILLER_8_271 VDD VDD VSS VSS gf180mcu_fd_sc_mcu7t5v0__fill_1
XFILLER_39_142 VDD VDD VSS VSS gf180mcu_fd_sc_mcu7t5v0__fill_2
XFILLER_39_153 VDD VDD VSS VSS gf180mcu_fd_sc_mcu7t5v0__fill_1
XFILLER_39_186 VDD VDD VSS VSS gf180mcu_fd_sc_mcu7t5v0__fill_1
XFILLER_54_101 VDD VDD VSS VSS gf180mcu_fd_sc_mcu7t5v0__fillcap_4
Xu_core.delay_paths.u_trc0.gen_inv_stage\[41\].inv u_core.delay_paths.u_trc0.gen_inv_stage\[41\].inv/I
+ u_core.delay_paths.u_trc0.gen_inv_stage\[42\].inv/I VDD VDD VSS VSS gf180mcu_fd_sc_mcu7t5v0__inv_1
XTAP_TAPCELL_ROW_37_354 VDD VSS gf180mcu_fd_sc_mcu7t5v0__filltie
XPHY_EDGE_ROW_59_Left_120 VDD VSS gf180mcu_fd_sc_mcu7t5v0__endcap
XFILLER_10_204 VDD VDD VSS VSS gf180mcu_fd_sc_mcu7t5v0__fillcap_8
XFILLER_24_69 VDD VDD VSS VSS gf180mcu_fd_sc_mcu7t5v0__fillcap_16
Xu_core.delay_paths.u_trc0.gen_inv_stage\[56\].inv u_core.delay_paths.u_trc0.gen_inv_stage\[56\].inv/I
+ u_core.delay_paths.u_trc0.gen_inv_stage\[57\].inv/I VDD VDD VSS VSS gf180mcu_fd_sc_mcu7t5v0__inv_2
XFILLER_49_66 VDD VDD VSS VSS gf180mcu_fd_sc_mcu7t5v0__fillcap_4
XFILLER_60_104 VDD VDD VSS VSS gf180mcu_fd_sc_mcu7t5v0__fillcap_32
X_424_ _620_/Q _425_/A2 _517_/S VDD VDD VSS VSS gf180mcu_fd_sc_mcu7t5v0__nand2_1
XFILLER_60_8 VDD VDD VSS VSS gf180mcu_fd_sc_mcu7t5v0__fill_1
X_355_ _718_/I _719_/I _603_/D VDD VDD VSS VSS gf180mcu_fd_sc_mcu7t5v0__xor2_1
XFILLER_32_351 VDD VDD VSS VSS gf180mcu_fd_sc_mcu7t5v0__fillcap_4
XTAP_TAPCELL_ROW_34_335 VDD VSS gf180mcu_fd_sc_mcu7t5v0__filltie
XFILLER_27_156 VDD VDD VSS VSS gf180mcu_fd_sc_mcu7t5v0__fill_1
XFILLER_23_362 VDD VDD VSS VSS gf180mcu_fd_sc_mcu7t5v0__fill_1
XPHY_EDGE_ROW_14_Right_14 VDD VSS gf180mcu_fd_sc_mcu7t5v0__endcap
XFILLER_2_255 VDD VDD VSS VSS gf180mcu_fd_sc_mcu7t5v0__fillcap_4
XPHY_EDGE_ROW_23_Right_23 VDD VSS gf180mcu_fd_sc_mcu7t5v0__endcap
XFILLER_18_101 VDD VDD VSS VSS gf180mcu_fd_sc_mcu7t5v0__fillcap_4
XTAP_TAPCELL_ROW_48_416 VDD VSS gf180mcu_fd_sc_mcu7t5v0__filltie
XFILLER_41_170 VDD VDD VSS VSS gf180mcu_fd_sc_mcu7t5v0__fill_2
X_407_ _638_/Q _664_/Q _663_/Q _408_/I VDD VDD VSS VSS gf180mcu_fd_sc_mcu7t5v0__aoi21_1
X_338_ _344_/A2 _346_/A1 _338_/B _350_/A2 VDD VDD VSS VSS gf180mcu_fd_sc_mcu7t5v0__aoi21_1
XTAP_TAPCELL_ROW_31_316 VDD VSS gf180mcu_fd_sc_mcu7t5v0__filltie
XPHY_EDGE_ROW_32_Right_32 VDD VSS gf180mcu_fd_sc_mcu7t5v0__endcap
XFILLER_37_2 VDD VDD VSS VSS gf180mcu_fd_sc_mcu7t5v0__fillcap_32
XPHY_EDGE_ROW_41_Right_41 VDD VSS gf180mcu_fd_sc_mcu7t5v0__endcap
XPHY_EDGE_ROW_22_Left_83 VDD VSS gf180mcu_fd_sc_mcu7t5v0__endcap
XPHY_EDGE_ROW_50_Right_50 VDD VSS gf180mcu_fd_sc_mcu7t5v0__endcap
Xu_core.delay_paths.u_trc3.gen_inv_stage\[32\].inv u_core.delay_paths.u_trc3.gen_inv_stage\[32\].inv/I
+ u_core.delay_paths.u_trc3.gen_inv_stage\[33\].inv/I VDD VDD VSS VSS gf180mcu_fd_sc_mcu7t5v0__inv_1
XFILLER_46_34 VDD VDD VSS VSS gf180mcu_fd_sc_mcu7t5v0__fill_1
Xu_core.delay_paths.u_trc3.gen_inv_stage\[47\].inv u_core.delay_paths.u_trc3.gen_inv_stage\[47\].inv/I
+ _725_/I VDD VDD VSS VSS gf180mcu_fd_sc_mcu7t5v0__inv_1
Xmax_cap13 _539_/S _540_/S VDD VDD VSS VSS gf180mcu_fd_sc_mcu7t5v0__buf_2
XFILLER_15_115 VDD VDD VSS VSS gf180mcu_fd_sc_mcu7t5v0__fillcap_16
XFILLER_30_107 VDD VDD VSS VSS gf180mcu_fd_sc_mcu7t5v0__fillcap_8
XFILLER_46_89 VDD VDD VSS VSS gf180mcu_fd_sc_mcu7t5v0__fill_1
XFILLER_11_343 VDD VDD VSS VSS gf180mcu_fd_sc_mcu7t5v0__fillcap_4
XFILLER_7_303 VDD VDD VSS VSS gf180mcu_fd_sc_mcu7t5v0__fillcap_32
XFILLER_7_347 VDD VDD VSS VSS gf180mcu_fd_sc_mcu7t5v0__fill_2
XFILLER_46_240 VDD VDD VSS VSS gf180mcu_fd_sc_mcu7t5v0__fillcap_4
XFILLER_29_218 VDD VDD VSS VSS gf180mcu_fd_sc_mcu7t5v0__fill_1
XFILLER_12_107 VDD VDD VSS VSS gf180mcu_fd_sc_mcu7t5v0__fill_1
XFILLER_16_37 VDD VDD VSS VSS gf180mcu_fd_sc_mcu7t5v0__fillcap_64
XFILLER_37_262 VDD VDD VSS VSS gf180mcu_fd_sc_mcu7t5v0__fillcap_4
XFILLER_37_273 VDD VDD VSS VSS gf180mcu_fd_sc_mcu7t5v0__fillcap_4
XFILLER_40_427 VDD VDD VSS VSS gf180mcu_fd_sc_mcu7t5v0__fill_2
XTAP_TAPCELL_ROW_50_433 VDD VSS gf180mcu_fd_sc_mcu7t5v0__filltie
XFILLER_4_317 VDD VDD VSS VSS gf180mcu_fd_sc_mcu7t5v0__fillcap_32
XFILLER_57_66 VDD VDD VSS VSS gf180mcu_fd_sc_mcu7t5v0__fillcap_4
X_672_ _672_/D _677_/RN _699_/CLK _672_/Q VDD VDD VSS VSS gf180mcu_fd_sc_mcu7t5v0__dffrnq_1
XFILLER_43_298 VDD VDD VSS VSS gf180mcu_fd_sc_mcu7t5v0__fill_2
Xu_core.delay_paths.u_trc2.gen_inv_stage\[71\].inv u_core.delay_paths.u_trc2.gen_inv_stage\[71\].inv/I
+ u_core.delay_paths.u_trc2.gen_inv_stage\[72\].inv/I VDD VDD VSS VSS gf180mcu_fd_sc_mcu7t5v0__inv_1
Xu_core.delay_paths.u_trc2.gen_inv_stage\[86\].inv u_core.delay_paths.u_trc2.gen_inv_stage\[86\].inv/I
+ u_core.delay_paths.u_trc2.gen_inv_stage\[87\].inv/I VDD VDD VSS VSS gf180mcu_fd_sc_mcu7t5v0__inv_1
XPHY_EDGE_ROW_4_Right_4 VDD VSS gf180mcu_fd_sc_mcu7t5v0__endcap
XFILLER_57_346 VDD VDD VSS VSS gf180mcu_fd_sc_mcu7t5v0__fillcap_4
Xu_core.delay_paths.u_trc2.gen_inv_stage\[24\].inv u_core.delay_paths.u_trc2.gen_inv_stage\[24\].inv/I
+ u_core.delay_paths.u_trc2.gen_inv_stage\[25\].inv/I VDD VDD VSS VSS gf180mcu_fd_sc_mcu7t5v0__inv_1
XPHY_EDGE_ROW_40_Left_101 VDD VSS gf180mcu_fd_sc_mcu7t5v0__endcap
Xu_core.delay_paths.u_trc2.gen_inv_stage\[39\].inv u_core.delay_paths.u_trc2.gen_inv_stage\[39\].inv/I
+ u_core.delay_paths.u_trc2.gen_inv_stage\[40\].inv/I VDD VDD VSS VSS gf180mcu_fd_sc_mcu7t5v0__inv_1
XFILLER_0_331 VDD VDD VSS VSS gf180mcu_fd_sc_mcu7t5v0__fillcap_8
XFILLER_0_342 VDD VDD VSS VSS gf180mcu_fd_sc_mcu7t5v0__fillcap_32
X_724_ _724_/I _724_/Z VDD VDD VSS VSS gf180mcu_fd_sc_mcu7t5v0__buf_1
X_655_ _655_/D _693_/RN _693_/CLK _655_/Q VDD VDD VSS VSS gf180mcu_fd_sc_mcu7t5v0__dffrnq_1
X_586_ _602_/I _613_/RN VDD VDD VSS VSS gf180mcu_fd_sc_mcu7t5v0__clkinv_1
XTAP_TAPCELL_ROW_18_238 VDD VSS gf180mcu_fd_sc_mcu7t5v0__filltie
Xu_core.delay_paths.u_trc1.gen_inv_stage\[111\].inv u_core.delay_paths.u_trc1.gen_inv_stage\[111\].inv/I
+ u_core.delay_paths.u_trc1.gen_inv_stage\[112\].inv/I VDD VDD VSS VSS gf180mcu_fd_sc_mcu7t5v0__inv_1
Xu_core.delay_paths.u_trc1.gen_inv_stage\[126\].inv u_core.delay_paths.u_trc1.gen_inv_stage\[126\].inv/I
+ u_core.delay_paths.u_trc1.gen_inv_stage\[127\].inv/I VDD VDD VSS VSS gf180mcu_fd_sc_mcu7t5v0__inv_1
XTAP_TAPCELL_ROW_1_139 VDD VSS gf180mcu_fd_sc_mcu7t5v0__filltie
XFILLER_45_316 VDD VDD VSS VSS gf180mcu_fd_sc_mcu7t5v0__fillcap_32
XFILLER_54_34 VDD VDD VSS VSS gf180mcu_fd_sc_mcu7t5v0__fill_1
XFILLER_60_308 VDD VDD VSS VSS gf180mcu_fd_sc_mcu7t5v0__fillcap_32
X_440_ _453_/B _440_/A2 _627_/D VDD VDD VSS VSS gf180mcu_fd_sc_mcu7t5v0__nor2_1
X_371_ _374_/A2 _368_/Z _371_/Z VDD VDD VSS VSS gf180mcu_fd_sc_mcu7t5v0__and2_1
XTAP_TAPCELL_ROW_15_219 VDD VSS gf180mcu_fd_sc_mcu7t5v0__filltie
XFILLER_21_290 VDD VDD VSS VSS gf180mcu_fd_sc_mcu7t5v0__fillcap_4
Xu_core.delay_paths.u_trc1.gen_inv_stage\[1\].inv u_core.delay_paths.u_trc1.gen_inv_stage\[1\].inv/I
+ u_core.delay_paths.u_trc1.gen_inv_stage\[2\].inv/I VDD VDD VSS VSS gf180mcu_fd_sc_mcu7t5v0__inv_1
XFILLER_9_228 VDD VDD VSS VSS gf180mcu_fd_sc_mcu7t5v0__fill_2
XFILLER_48_154 VDD VDD VSS VSS gf180mcu_fd_sc_mcu7t5v0__fill_1
Xu_core.delay_paths.u_trc3.gen_inv_stage\[0\].inv _724_/I u_core.delay_paths.u_trc3.gen_inv_stage\[1\].inv/I
+ VDD VDD VSS VSS gf180mcu_fd_sc_mcu7t5v0__inv_1
X_638_ _638_/D _704_/RN _688_/CLK _638_/Q VDD VDD VSS VSS gf180mcu_fd_sc_mcu7t5v0__dffsnq_1
X_569_ _569_/I _658_/D VDD VDD VSS VSS gf180mcu_fd_sc_mcu7t5v0__clkinv_1
Xu_core.delay_paths.u_trc1.gen_inv_stage\[63\].inv u_core.delay_paths.u_trc1.gen_inv_stage\[63\].inv/I
+ u_core.delay_paths.u_trc1.gen_inv_stage\[64\].inv/I VDD VDD VSS VSS gf180mcu_fd_sc_mcu7t5v0__inv_1
Xu_core.delay_paths.u_trc1.gen_inv_stage\[78\].inv u_core.delay_paths.u_trc1.gen_inv_stage\[78\].inv/I
+ u_core.delay_paths.u_trc1.gen_inv_stage\[79\].inv/I VDD VDD VSS VSS gf180mcu_fd_sc_mcu7t5v0__inv_1
XFILLER_27_316 VDD VDD VSS VSS gf180mcu_fd_sc_mcu7t5v0__fillcap_4
XFILLER_27_349 VDD VDD VSS VSS gf180mcu_fd_sc_mcu7t5v0__fill_1
Xu_core.delay_paths.u_trc1.gen_inv_stage\[16\].inv u_core.delay_paths.u_trc1.gen_inv_stage\[16\].inv/I
+ u_core.delay_paths.u_trc1.gen_inv_stage\[17\].inv/I VDD VDD VSS VSS gf180mcu_fd_sc_mcu7t5v0__inv_1
XTAP_TAPCELL_ROW_37_355 VDD VSS gf180mcu_fd_sc_mcu7t5v0__filltie
XFILLER_24_37 VDD VDD VSS VSS gf180mcu_fd_sc_mcu7t5v0__fillcap_32
XTAP_TAPCELL_ROW_28_300 VDD VSS gf180mcu_fd_sc_mcu7t5v0__filltie
XFILLER_26_382 VDD VDD VSS VSS gf180mcu_fd_sc_mcu7t5v0__fill_2
XFILLER_41_341 VDD VDD VSS VSS gf180mcu_fd_sc_mcu7t5v0__fillcap_8
XFILLER_41_352 VDD VDD VSS VSS gf180mcu_fd_sc_mcu7t5v0__fillcap_64
XFILLER_60_138 VDD VDD VSS VSS gf180mcu_fd_sc_mcu7t5v0__fillcap_16
X_423_ _423_/A1 _419_/Z _423_/B _697_/D VDD VDD VSS VSS gf180mcu_fd_sc_mcu7t5v0__aoi21_1
X_354_ _647_/Q _693_/D _354_/Z VDD VDD VSS VSS gf180mcu_fd_sc_mcu7t5v0__and2_1
XFILLER_5_220 VDD VDD VSS VSS gf180mcu_fd_sc_mcu7t5v0__fillcap_4
XFILLER_5_242 VDD VDD VSS VSS gf180mcu_fd_sc_mcu7t5v0__fillcap_16
XFILLER_5_297 VDD VDD VSS VSS gf180mcu_fd_sc_mcu7t5v0__fill_2
XFILLER_36_135 VDD VDD VSS VSS gf180mcu_fd_sc_mcu7t5v0__fill_2
XTAP_TAPCELL_ROW_42_380 VDD VSS gf180mcu_fd_sc_mcu7t5v0__filltie
XTAP_TAPCELL_ROW_34_336 VDD VSS gf180mcu_fd_sc_mcu7t5v0__filltie
XFILLER_55_422 VDD VDD VSS VSS gf180mcu_fd_sc_mcu7t5v0__fillcap_8
Xu_core.delay_paths.u_trc0.gen_inv_stage\[151\].inv u_core.delay_paths.u_trc0.gen_inv_stage\[151\].inv/I
+ u_core.delay_paths.u_trc0.gen_inv_stage\[152\].inv/I VDD VDD VSS VSS gf180mcu_fd_sc_mcu7t5v0__inv_1
XFILLER_23_352 VDD VDD VSS VSS gf180mcu_fd_sc_mcu7t5v0__fillcap_8
XFILLER_27_146 VDD VDD VSS VSS gf180mcu_fd_sc_mcu7t5v0__fill_2
Xu_core.delay_paths.u_trc0.gen_inv_stage\[166\].inv u_core.delay_paths.u_trc0.gen_inv_stage\[166\].inv/I
+ u_core.delay_paths.u_trc0.gen_inv_stage\[167\].inv/I VDD VDD VSS VSS gf180mcu_fd_sc_mcu7t5v0__inv_1
XFILLER_50_171 VDD VDD VSS VSS gf180mcu_fd_sc_mcu7t5v0__fillcap_4
Xu_core.delay_paths.u_trc0.gen_inv_stage\[104\].inv u_core.delay_paths.u_trc0.gen_inv_stage\[104\].inv/I
+ u_core.delay_paths.u_trc0.gen_inv_stage\[105\].inv/I VDD VDD VSS VSS gf180mcu_fd_sc_mcu7t5v0__inv_2
Xu_core.delay_paths.u_trc0.gen_inv_stage\[119\].inv u_core.delay_paths.u_trc0.gen_inv_stage\[119\].inv/I
+ u_core.delay_paths.u_trc0.gen_inv_stage\[120\].inv/I VDD VDD VSS VSS gf180mcu_fd_sc_mcu7t5v0__inv_2
XTAP_TAPCELL_ROW_48_417 VDD VSS gf180mcu_fd_sc_mcu7t5v0__filltie
XFILLER_25_80 VDD VDD VSS VSS gf180mcu_fd_sc_mcu7t5v0__fill_2
XFILLER_41_193 VDD VDD VSS VSS gf180mcu_fd_sc_mcu7t5v0__fill_1
X_406_ _663_/Q _664_/Q _472_/A1 VDD VDD VSS VSS gf180mcu_fd_sc_mcu7t5v0__nor2_1
X_337_ _544_/A1 _634_/Q _337_/B _346_/A1 VDD VDD VSS VSS gf180mcu_fd_sc_mcu7t5v0__oai21_1
XTAP_TAPCELL_ROW_31_317 VDD VSS gf180mcu_fd_sc_mcu7t5v0__filltie
Xu_core.delay_paths.u_trc0.gen_inv_stage\[40\].inv u_core.delay_paths.u_trc0.gen_inv_stage\[40\].inv/I
+ u_core.delay_paths.u_trc0.gen_inv_stage\[41\].inv/I VDD VDD VSS VSS gf180mcu_fd_sc_mcu7t5v0__inv_1
XFILLER_37_422 VDD VDD VSS VSS gf180mcu_fd_sc_mcu7t5v0__fillcap_8
XFILLER_49_282 VDD VDD VSS VSS gf180mcu_fd_sc_mcu7t5v0__fillcap_64
Xu_core.delay_paths.u_trc0.gen_inv_stage\[55\].inv u_core.delay_paths.u_trc0.gen_inv_stage\[55\].inv/I
+ u_core.delay_paths.u_trc0.gen_inv_stage\[56\].inv/I VDD VDD VSS VSS gf180mcu_fd_sc_mcu7t5v0__inv_2
Xmax_cap14 _455_/A2 _447_/A2 VDD VDD VSS VSS gf180mcu_fd_sc_mcu7t5v0__buf_2
XFILLER_34_403 VDD VDD VSS VSS gf180mcu_fd_sc_mcu7t5v0__fillcap_8
XFILLER_25_414 VDD VDD VSS VSS gf180mcu_fd_sc_mcu7t5v0__fillcap_4
XFILLER_37_230 VDD VDD VSS VSS gf180mcu_fd_sc_mcu7t5v0__fillcap_32
XFILLER_32_37 VDD VDD VSS VSS gf180mcu_fd_sc_mcu7t5v0__fill_2
XFILLER_20_163 VDD VDD VSS VSS gf180mcu_fd_sc_mcu7t5v0__fillcap_4
XFILLER_31_417 VDD VDD VSS VSS gf180mcu_fd_sc_mcu7t5v0__fill_2
XFILLER_43_244 VDD VDD VSS VSS gf180mcu_fd_sc_mcu7t5v0__fillcap_4
X_671_ _671_/D _677_/RN _682_/CLK _671_/Q VDD VDD VSS VSS gf180mcu_fd_sc_mcu7t5v0__dffrnq_1
XFILLER_7_112 VDD VDD VSS VSS gf180mcu_fd_sc_mcu7t5v0__fillcap_4
XFILLER_22_428 VDD VDD VSS VSS gf180mcu_fd_sc_mcu7t5v0__fill_2
Xu_core.delay_paths.u_trc3.gen_inv_stage\[31\].inv u_core.delay_paths.u_trc3.gen_inv_stage\[31\].inv/I
+ u_core.delay_paths.u_trc3.gen_inv_stage\[32\].inv/I VDD VDD VSS VSS gf180mcu_fd_sc_mcu7t5v0__inv_1
Xu_core.delay_paths.u_trc3.gen_inv_stage\[46\].inv u_core.delay_paths.u_trc3.gen_inv_stage\[46\].inv/I
+ u_core.delay_paths.u_trc3.gen_inv_stage\[47\].inv/I VDD VDD VSS VSS gf180mcu_fd_sc_mcu7t5v0__inv_1
XFILLER_40_247 VDD VDD VSS VSS gf180mcu_fd_sc_mcu7t5v0__fillcap_4
XFILLER_0_310 VDD VDD VSS VSS gf180mcu_fd_sc_mcu7t5v0__fill_1
XFILLER_0_376 VDD VDD VSS VSS gf180mcu_fd_sc_mcu7t5v0__fill_2
XFILLER_0_387 VDD VDD VSS VSS gf180mcu_fd_sc_mcu7t5v0__fillcap_16
X_723_ _723_/I _723_/Z VDD VDD VSS VSS gf180mcu_fd_sc_mcu7t5v0__buf_1
X_654_ _654_/D _661_/RN _693_/CLK _654_/Q VDD VDD VSS VSS gf180mcu_fd_sc_mcu7t5v0__dffrnq_1
XFILLER_16_200 VDD VDD VSS VSS gf180mcu_fd_sc_mcu7t5v0__fillcap_8
XFILLER_16_244 VDD VDD VSS VSS gf180mcu_fd_sc_mcu7t5v0__fill_1
XFILLER_16_299 VDD VDD VSS VSS gf180mcu_fd_sc_mcu7t5v0__fill_2
X_585_ _602_/I _612_/RN VDD VDD VSS VSS gf180mcu_fd_sc_mcu7t5v0__clkinv_1
XTAP_TAPCELL_ROW_18_239 VDD VSS gf180mcu_fd_sc_mcu7t5v0__filltie
XFILLER_8_421 VDD VDD VSS VSS gf180mcu_fd_sc_mcu7t5v0__fillcap_8
XFILLER_12_2 VDD VDD VSS VSS gf180mcu_fd_sc_mcu7t5v0__fillcap_32
XFILLER_54_317 VDD VDD VSS VSS gf180mcu_fd_sc_mcu7t5v0__fillcap_64
XFILLER_22_247 VDD VDD VSS VSS gf180mcu_fd_sc_mcu7t5v0__fill_2
Xfanout29 _702_/RN _675_/RN VDD VDD VSS VSS gf180mcu_fd_sc_mcu7t5v0__dlyb_1
XFILLER_38_47 VDD VDD VSS VSS gf180mcu_fd_sc_mcu7t5v0__fill_1
XFILLER_38_69 VDD VDD VSS VSS gf180mcu_fd_sc_mcu7t5v0__fill_2
X_370_ _374_/A2 _368_/Z _388_/B VDD VDD VSS VSS gf180mcu_fd_sc_mcu7t5v0__or2_1
XFILLER_0_151 VDD VDD VSS VSS gf180mcu_fd_sc_mcu7t5v0__fillcap_4
Xu_core.delay_paths.u_trc2.gen_inv_stage\[70\].inv u_core.delay_paths.u_trc2.gen_inv_stage\[70\].inv/I
+ u_core.delay_paths.u_trc2.gen_inv_stage\[71\].inv/I VDD VDD VSS VSS gf180mcu_fd_sc_mcu7t5v0__inv_1
XFILLER_36_317 VDD VDD VSS VSS gf180mcu_fd_sc_mcu7t5v0__fill_2
XFILLER_48_144 VDD VDD VSS VSS gf180mcu_fd_sc_mcu7t5v0__fill_2
XFILLER_48_177 VDD VDD VSS VSS gf180mcu_fd_sc_mcu7t5v0__fillcap_64
Xu_core.delay_paths.u_trc2.gen_inv_stage\[85\].inv u_core.delay_paths.u_trc2.gen_inv_stage\[85\].inv/I
+ u_core.delay_paths.u_trc2.gen_inv_stage\[86\].inv/I VDD VDD VSS VSS gf180mcu_fd_sc_mcu7t5v0__inv_1
X_637_ _637_/D _695_/RN _694_/CLK _637_/Q VDD VDD VSS VSS gf180mcu_fd_sc_mcu7t5v0__dffrnq_1
X_568_ _658_/Q _574_/A1 _568_/B1 _582_/A1 _569_/I VDD VDD VSS VSS gf180mcu_fd_sc_mcu7t5v0__aoi22_1
X_499_ _674_/Q _504_/S _500_/B VDD VDD VSS VSS gf180mcu_fd_sc_mcu7t5v0__nor2_1
XFILLER_8_251 VDD VDD VSS VSS gf180mcu_fd_sc_mcu7t5v0__fillcap_16
Xu_core.delay_paths.u_trc2.gen_inv_stage\[23\].inv u_core.delay_paths.u_trc2.gen_inv_stage\[23\].inv/I
+ u_core.delay_paths.u_trc2.gen_inv_stage\[24\].inv/I VDD VDD VSS VSS gf180mcu_fd_sc_mcu7t5v0__inv_1
Xu_core.delay_paths.u_trc2.gen_inv_stage\[38\].inv u_core.delay_paths.u_trc2.gen_inv_stage\[38\].inv/I
+ u_core.delay_paths.u_trc2.gen_inv_stage\[39\].inv/I VDD VDD VSS VSS gf180mcu_fd_sc_mcu7t5v0__inv_1
XFILLER_39_133 VDD VDD VSS VSS gf180mcu_fd_sc_mcu7t5v0__fillcap_4
XFILLER_39_144 VDD VDD VSS VSS gf180mcu_fd_sc_mcu7t5v0__fill_1
XFILLER_40_37 VDD VDD VSS VSS gf180mcu_fd_sc_mcu7t5v0__fillcap_16
XFILLER_2_427 VDD VDD VSS VSS gf180mcu_fd_sc_mcu7t5v0__fill_2
XFILLER_18_317 VDD VDD VSS VSS gf180mcu_fd_sc_mcu7t5v0__fillcap_8
XFILLER_45_136 VDD VDD VSS VSS gf180mcu_fd_sc_mcu7t5v0__fillcap_4
XFILLER_45_158 VDD VDD VSS VSS gf180mcu_fd_sc_mcu7t5v0__fill_2
XTAP_TAPCELL_ROW_28_301 VDD VSS gf180mcu_fd_sc_mcu7t5v0__filltie
Xu_core.delay_paths.u_trc1.gen_inv_stage\[110\].inv u_core.delay_paths.u_trc1.gen_inv_stage\[110\].inv/I
+ u_core.delay_paths.u_trc1.gen_inv_stage\[111\].inv/I VDD VDD VSS VSS gf180mcu_fd_sc_mcu7t5v0__inv_1
X_422_ _422_/A1 _422_/A2 _418_/B _702_/Q _423_/B VDD VDD VSS VSS gf180mcu_fd_sc_mcu7t5v0__oai31_1
X_353_ _343_/Z _349_/Z _353_/B _693_/D VDD VDD VSS VSS gf180mcu_fd_sc_mcu7t5v0__oai21_1
Xu_core.delay_paths.u_trc1.gen_inv_stage\[125\].inv u_core.delay_paths.u_trc1.gen_inv_stage\[125\].inv/I
+ u_core.delay_paths.u_trc1.gen_inv_stage\[126\].inv/I VDD VDD VSS VSS gf180mcu_fd_sc_mcu7t5v0__inv_1
XFILLER_36_103 VDD VDD VSS VSS gf180mcu_fd_sc_mcu7t5v0__fill_2
XFILLER_36_158 VDD VDD VSS VSS gf180mcu_fd_sc_mcu7t5v0__fillcap_4
XTAP_TAPCELL_ROW_34_337 VDD VSS gf180mcu_fd_sc_mcu7t5v0__filltie
XTAP_TAPCELL_ROW_42_381 VDD VSS gf180mcu_fd_sc_mcu7t5v0__filltie
XFILLER_59_206 VDD VDD VSS VSS gf180mcu_fd_sc_mcu7t5v0__fillcap_4
Xu_core.delay_paths.u_trc1.gen_inv_stage\[0\].inv _720_/I u_core.delay_paths.u_trc1.gen_inv_stage\[1\].inv/I
+ VDD VDD VSS VSS gf180mcu_fd_sc_mcu7t5v0__inv_1
XFILLER_23_331 VDD VDD VSS VSS gf180mcu_fd_sc_mcu7t5v0__fillcap_4
XFILLER_23_397 VDD VDD VSS VSS gf180mcu_fd_sc_mcu7t5v0__fillcap_8
XFILLER_2_235 VDD VDD VSS VSS gf180mcu_fd_sc_mcu7t5v0__fillcap_8
XFILLER_2_279 VDD VDD VSS VSS gf180mcu_fd_sc_mcu7t5v0__fillcap_16
XFILLER_33_139 VDD VDD VSS VSS gf180mcu_fd_sc_mcu7t5v0__fill_1
Xu_core.delay_paths.u_trc1.gen_inv_stage\[62\].inv u_core.delay_paths.u_trc1.gen_inv_stage\[62\].inv/I
+ u_core.delay_paths.u_trc1.gen_inv_stage\[63\].inv/I VDD VDD VSS VSS gf180mcu_fd_sc_mcu7t5v0__inv_1
XTAP_TAPCELL_ROW_48_418 VDD VSS gf180mcu_fd_sc_mcu7t5v0__filltie
XFILLER_41_172 VDD VDD VSS VSS gf180mcu_fd_sc_mcu7t5v0__fill_1
Xu_core.delay_paths.u_trc1.gen_inv_stage\[77\].inv u_core.delay_paths.u_trc1.gen_inv_stage\[77\].inv/I
+ u_core.delay_paths.u_trc1.gen_inv_stage\[78\].inv/I VDD VDD VSS VSS gf180mcu_fd_sc_mcu7t5v0__inv_1
X_405_ _405_/A1 _422_/A1 _422_/A2 _418_/B _701_/D VDD VDD VSS VSS gf180mcu_fd_sc_mcu7t5v0__nor4_1
X_336_ _635_/Q _653_/Q _345_/B VDD VDD VSS VSS gf180mcu_fd_sc_mcu7t5v0__xor2_1
XTAP_TAPCELL_ROW_31_318 VDD VSS gf180mcu_fd_sc_mcu7t5v0__filltie
Xu_core.delay_paths.u_trc1.gen_inv_stage\[15\].inv u_core.delay_paths.u_trc1.gen_inv_stage\[15\].inv/I
+ u_core.delay_paths.u_trc1.gen_inv_stage\[16\].inv/I VDD VDD VSS VSS gf180mcu_fd_sc_mcu7t5v0__inv_1
XFILLER_2_74 VDD VDD VSS VSS gf180mcu_fd_sc_mcu7t5v0__fill_1
XFILLER_24_139 VDD VDD VSS VSS gf180mcu_fd_sc_mcu7t5v0__fill_2
XFILLER_15_139 VDD VDD VSS VSS gf180mcu_fd_sc_mcu7t5v0__fill_1
XFILLER_11_72 VDD VDD VSS VSS gf180mcu_fd_sc_mcu7t5v0__fillcap_8
XFILLER_11_94 VDD VDD VSS VSS gf180mcu_fd_sc_mcu7t5v0__fillcap_8
XFILLER_7_349 VDD VDD VSS VSS gf180mcu_fd_sc_mcu7t5v0__fill_1
XFILLER_34_415 VDD VDD VSS VSS gf180mcu_fd_sc_mcu7t5v0__fill_1
Xu_core.delay_paths.u_trc0.gen_inv_stage\[150\].inv u_core.delay_paths.u_trc0.gen_inv_stage\[150\].inv/I
+ u_core.delay_paths.u_trc0.gen_inv_stage\[151\].inv/I VDD VDD VSS VSS gf180mcu_fd_sc_mcu7t5v0__inv_1
X_319_ _621_/Q _425_/A2 VDD VDD VSS VSS gf180mcu_fd_sc_mcu7t5v0__clkinv_1
XFILLER_29_209 VDD VDD VSS VSS gf180mcu_fd_sc_mcu7t5v0__fill_1
XFILLER_42_2 VDD VDD VSS VSS gf180mcu_fd_sc_mcu7t5v0__fillcap_32
Xu_core.delay_paths.u_trc0.gen_inv_stage\[165\].inv u_core.delay_paths.u_trc0.gen_inv_stage\[165\].inv/I
+ u_core.delay_paths.u_trc0.gen_inv_stage\[166\].inv/I VDD VDD VSS VSS gf180mcu_fd_sc_mcu7t5v0__inv_1
XFILLER_25_426 VDD VDD VSS VSS gf180mcu_fd_sc_mcu7t5v0__fillcap_4
XFILLER_40_429 VDD VDD VSS VSS gf180mcu_fd_sc_mcu7t5v0__fill_1
Xu_core.delay_paths.u_trc0.gen_inv_stage\[118\].inv u_core.delay_paths.u_trc0.gen_inv_stage\[118\].inv/I
+ u_core.delay_paths.u_trc0.gen_inv_stage\[119\].inv/I VDD VDD VSS VSS gf180mcu_fd_sc_mcu7t5v0__inv_2
Xu_core.delay_paths.u_trc0.gen_inv_stage\[103\].inv u_core.delay_paths.u_trc0.gen_inv_stage\[103\].inv/I
+ u_core.delay_paths.u_trc0.gen_inv_stage\[104\].inv/I VDD VDD VSS VSS gf180mcu_fd_sc_mcu7t5v0__inv_2
X_670_ _670_/D _677_/RN _682_/CLK _670_/Q VDD VDD VSS VSS gf180mcu_fd_sc_mcu7t5v0__dffrnq_1
XFILLER_28_297 VDD VDD VSS VSS gf180mcu_fd_sc_mcu7t5v0__fillcap_4
XFILLER_43_212 VDD VDD VSS VSS gf180mcu_fd_sc_mcu7t5v0__fillcap_32
XFILLER_11_142 VDD VDD VSS VSS gf180mcu_fd_sc_mcu7t5v0__fill_2
Xu_core.delay_paths.u_trc0.gen_inv_stage\[54\].inv u_core.delay_paths.u_trc0.gen_inv_stage\[54\].inv/I
+ u_core.delay_paths.u_trc0.gen_inv_stage\[55\].inv/I VDD VDD VSS VSS gf180mcu_fd_sc_mcu7t5v0__inv_2
XFILLER_3_352 VDD VDD VSS VSS gf180mcu_fd_sc_mcu7t5v0__fillcap_16
Xu_core.delay_paths.u_trc0.gen_inv_stage\[69\].inv u_core.delay_paths.u_trc0.gen_inv_stage\[69\].inv/I
+ u_core.delay_paths.u_trc0.gen_inv_stage\[70\].inv/I VDD VDD VSS VSS gf180mcu_fd_sc_mcu7t5v0__clkinv_1
XFILLER_19_297 VDD VDD VSS VSS gf180mcu_fd_sc_mcu7t5v0__fillcap_8
XFILLER_34_267 VDD VDD VSS VSS gf180mcu_fd_sc_mcu7t5v0__fill_2
XFILLER_25_212 VDD VDD VSS VSS gf180mcu_fd_sc_mcu7t5v0__fillcap_4
XFILLER_4_149 VDD VDD VSS VSS gf180mcu_fd_sc_mcu7t5v0__fillcap_16
XFILLER_56_381 VDD VDD VSS VSS gf180mcu_fd_sc_mcu7t5v0__fillcap_4
X_722_ _722_/I _722_/Z VDD VDD VSS VSS gf180mcu_fd_sc_mcu7t5v0__buf_1
X_653_ _653_/D _661_/RN _703_/CLK _653_/Q VDD VDD VSS VSS gf180mcu_fd_sc_mcu7t5v0__dffrnq_1
X_584_ _584_/A1 _584_/A2 _584_/B1 _584_/B2 _661_/D VDD VDD VSS VSS gf180mcu_fd_sc_mcu7t5v0__oai22_1
XTAP_TAPCELL_ROW_26_284 VDD VSS gf180mcu_fd_sc_mcu7t5v0__filltie
Xfanout19 _699_/Q _547_/A1 VDD VDD VSS VSS gf180mcu_fd_sc_mcu7t5v0__buf_1
XFILLER_38_37 VDD VDD VSS VSS gf180mcu_fd_sc_mcu7t5v0__fillcap_8
XFILLER_38_381 VDD VDD VSS VSS gf180mcu_fd_sc_mcu7t5v0__fillcap_4
XTAP_TAPCELL_ROW_0_130 VDD VSS gf180mcu_fd_sc_mcu7t5v0__filltie
XFILLER_5_414 VDD VDD VSS VSS gf180mcu_fd_sc_mcu7t5v0__fillcap_4
XFILLER_48_101 VDD VDD VSS VSS gf180mcu_fd_sc_mcu7t5v0__fillcap_4
Xu_core.delay_paths.u_trc3.gen_inv_stage\[45\].inv u_core.delay_paths.u_trc3.gen_inv_stage\[45\].inv/I
+ u_core.delay_paths.u_trc3.gen_inv_stage\[46\].inv/I VDD VDD VSS VSS gf180mcu_fd_sc_mcu7t5v0__inv_1
Xu_core.delay_paths.u_trc3.gen_inv_stage\[30\].inv u_core.delay_paths.u_trc3.gen_inv_stage\[30\].inv/I
+ u_core.delay_paths.u_trc3.gen_inv_stage\[31\].inv/I VDD VDD VSS VSS gf180mcu_fd_sc_mcu7t5v0__inv_1
XFILLER_48_167 VDD VDD VSS VSS gf180mcu_fd_sc_mcu7t5v0__fillcap_8
X_705_ _705_/D _705_/RN _705_/CLK _705_/Q VDD VDD VSS VSS gf180mcu_fd_sc_mcu7t5v0__dffrnq_1
X_636_ _636_/D _695_/RN _693_/CLK _636_/Q VDD VDD VSS VSS gf180mcu_fd_sc_mcu7t5v0__dffrnq_1
X_567_ _658_/Q _555_/I _568_/B1 VDD VDD VSS VSS gf180mcu_fd_sc_mcu7t5v0__nor2_1
XFILLER_44_91 VDD VDD VSS VSS gf180mcu_fd_sc_mcu7t5v0__fill_1
X_498_ _673_/Q _669_/Q _504_/S _673_/D VDD VDD VSS VSS gf180mcu_fd_sc_mcu7t5v0__mux2_2
XFILLER_35_340 VDD VDD VSS VSS gf180mcu_fd_sc_mcu7t5v0__fill_2
XFILLER_50_387 VDD VDD VSS VSS gf180mcu_fd_sc_mcu7t5v0__fillcap_32
XFILLER_18_329 VDD VDD VSS VSS gf180mcu_fd_sc_mcu7t5v0__fill_2
X_421_ _421_/A1 _421_/A2 _639_/Q _421_/C _432_/A2 VDD VDD VSS VSS gf180mcu_fd_sc_mcu7t5v0__oai211_1
XFILLER_26_384 VDD VDD VSS VSS gf180mcu_fd_sc_mcu7t5v0__fill_1
X_352_ _705_/Q _352_/A2 _352_/B1 _352_/B2 _693_/Q _353_/B VDD VDD VSS VSS gf180mcu_fd_sc_mcu7t5v0__aoi221_1
XFILLER_30_82 VDD VDD VSS VSS gf180mcu_fd_sc_mcu7t5v0__fillcap_16
XFILLER_36_115 VDD VDD VSS VSS gf180mcu_fd_sc_mcu7t5v0__fillcap_4
XTAP_TAPCELL_ROW_59_482 VDD VSS gf180mcu_fd_sc_mcu7t5v0__filltie
XFILLER_32_310 VDD VDD VSS VSS gf180mcu_fd_sc_mcu7t5v0__fillcap_4
X_619_ _626_/Q _619_/RN _695_/CLK _619_/Q VDD VDD VSS VSS gf180mcu_fd_sc_mcu7t5v0__dffrnq_1
XFILLER_32_387 VDD VDD VSS VSS gf180mcu_fd_sc_mcu7t5v0__fillcap_32
XTAP_TAPCELL_ROW_42_382 VDD VSS gf180mcu_fd_sc_mcu7t5v0__filltie
XFILLER_42_107 VDD VDD VSS VSS gf180mcu_fd_sc_mcu7t5v0__fill_2
XFILLER_2_203 VDD VDD VSS VSS gf180mcu_fd_sc_mcu7t5v0__fillcap_32
XFILLER_2_247 VDD VDD VSS VSS gf180mcu_fd_sc_mcu7t5v0__fillcap_8
Xu_core.delay_paths.u_trc2.gen_inv_stage\[84\].inv u_core.delay_paths.u_trc2.gen_inv_stage\[84\].inv/I
+ u_core.delay_paths.u_trc2.gen_inv_stage\[85\].inv/I VDD VDD VSS VSS gf180mcu_fd_sc_mcu7t5v0__inv_1
Xu_core.delay_paths.u_trc2.gen_inv_stage\[22\].inv u_core.delay_paths.u_trc2.gen_inv_stage\[22\].inv/I
+ u_core.delay_paths.u_trc2.gen_inv_stage\[23\].inv/I VDD VDD VSS VSS gf180mcu_fd_sc_mcu7t5v0__inv_1
XTAP_TAPCELL_ROW_48_419 VDD VSS gf180mcu_fd_sc_mcu7t5v0__filltie
XFILLER_14_332 VDD VDD VSS VSS gf180mcu_fd_sc_mcu7t5v0__fill_1
XFILLER_18_159 VDD VDD VSS VSS gf180mcu_fd_sc_mcu7t5v0__fill_2
XFILLER_26_181 VDD VDD VSS VSS gf180mcu_fd_sc_mcu7t5v0__fill_2
Xu_core.delay_paths.u_trc2.gen_inv_stage\[37\].inv u_core.delay_paths.u_trc2.gen_inv_stage\[37\].inv/I
+ u_core.delay_paths.u_trc2.gen_inv_stage\[38\].inv/I VDD VDD VSS VSS gf180mcu_fd_sc_mcu7t5v0__inv_1
X_404_ _416_/B1 _416_/B2 _418_/B VDD VDD VSS VSS gf180mcu_fd_sc_mcu7t5v0__nand2_1
X_335_ _635_/Q _653_/Q _337_/B VDD VDD VSS VSS gf180mcu_fd_sc_mcu7t5v0__xnor2_1
XTAP_TAPCELL_ROW_31_319 VDD VSS gf180mcu_fd_sc_mcu7t5v0__filltie
XFILLER_24_107 VDD VDD VSS VSS gf180mcu_fd_sc_mcu7t5v0__fillcap_32
XFILLER_2_64 VDD VDD VSS VSS gf180mcu_fd_sc_mcu7t5v0__fill_2
XPHY_EDGE_ROW_10_Right_10 VDD VSS gf180mcu_fd_sc_mcu7t5v0__endcap
XFILLER_17_170 VDD VDD VSS VSS gf180mcu_fd_sc_mcu7t5v0__fillcap_8
XFILLER_20_313 VDD VDD VSS VSS gf180mcu_fd_sc_mcu7t5v0__fill_2
XFILLER_52_427 VDD VDD VSS VSS gf180mcu_fd_sc_mcu7t5v0__fill_2
XFILLER_43_416 VDD VDD VSS VSS gf180mcu_fd_sc_mcu7t5v0__fillcap_4
XFILLER_46_37 VDD VDD VSS VSS gf180mcu_fd_sc_mcu7t5v0__fillcap_16
XFILLER_55_276 VDD VDD VSS VSS gf180mcu_fd_sc_mcu7t5v0__fillcap_4
Xu_core.delay_paths.u_trc1.gen_inv_stage\[124\].inv u_core.delay_paths.u_trc1.gen_inv_stage\[124\].inv/I
+ u_core.delay_paths.u_trc1.gen_inv_stage\[125\].inv/I VDD VDD VSS VSS gf180mcu_fd_sc_mcu7t5v0__inv_1
Xmax_cap16 _533_/S _534_/S VDD VDD VSS VSS gf180mcu_fd_sc_mcu7t5v0__buf_2
XFILLER_23_195 VDD VDD VSS VSS gf180mcu_fd_sc_mcu7t5v0__fill_1
Xu_core.delay_paths.u_trc1.gen_inv_stage\[139\].inv u_core.delay_paths.u_trc1.gen_inv_stage\[139\].inv/I
+ u_core.delay_paths.u_trc1.gen_inv_stage\[140\].inv/I VDD VDD VSS VSS gf180mcu_fd_sc_mcu7t5v0__inv_1
XFILLER_2_2 VDD VDD VSS VSS gf180mcu_fd_sc_mcu7t5v0__fillcap_32
XFILLER_46_232 VDD VDD VSS VSS gf180mcu_fd_sc_mcu7t5v0__fillcap_8
XFILLER_14_140 VDD VDD VSS VSS gf180mcu_fd_sc_mcu7t5v0__fillcap_4
XFILLER_14_151 VDD VDD VSS VSS gf180mcu_fd_sc_mcu7t5v0__fill_2
XPHY_EDGE_ROW_26_Left_87 VDD VSS gf180mcu_fd_sc_mcu7t5v0__endcap
XFILLER_6_350 VDD VDD VSS VSS gf180mcu_fd_sc_mcu7t5v0__fill_1
XFILLER_6_383 VDD VDD VSS VSS gf180mcu_fd_sc_mcu7t5v0__fill_2
X_318_ _318_/I _500_/A1 VDD VDD VSS VSS gf180mcu_fd_sc_mcu7t5v0__clkinv_1
XFILLER_35_2 VDD VDD VSS VSS gf180mcu_fd_sc_mcu7t5v0__fillcap_32
XFILLER_37_298 VDD VDD VSS VSS gf180mcu_fd_sc_mcu7t5v0__fill_1
XFILLER_32_39 VDD VDD VSS VSS gf180mcu_fd_sc_mcu7t5v0__fill_1
XFILLER_40_419 VDD VDD VSS VSS gf180mcu_fd_sc_mcu7t5v0__fillcap_8
Xu_core.delay_paths.u_trc1.gen_inv_stage\[61\].inv u_core.delay_paths.u_trc1.gen_inv_stage\[61\].inv/I
+ u_core.delay_paths.u_trc1.gen_inv_stage\[62\].inv/I VDD VDD VSS VSS gf180mcu_fd_sc_mcu7t5v0__inv_1
XFILLER_28_243 VDD VDD VSS VSS gf180mcu_fd_sc_mcu7t5v0__fill_2
Xu_core.delay_paths.u_trc1.gen_inv_stage\[76\].inv u_core.delay_paths.u_trc1.gen_inv_stage\[76\].inv/I
+ u_core.delay_paths.u_trc1.gen_inv_stage\[77\].inv/I VDD VDD VSS VSS gf180mcu_fd_sc_mcu7t5v0__inv_1
XFILLER_11_132 VDD VDD VSS VSS gf180mcu_fd_sc_mcu7t5v0__fillcap_8
XFILLER_31_419 VDD VDD VSS VSS gf180mcu_fd_sc_mcu7t5v0__fill_1
XFILLER_43_257 VDD VDD VSS VSS gf180mcu_fd_sc_mcu7t5v0__fillcap_16
Xu_core.delay_paths.u_trc1.gen_inv_stage\[14\].inv u_core.delay_paths.u_trc1.gen_inv_stage\[14\].inv/I
+ u_core.delay_paths.u_trc1.gen_inv_stage\[15\].inv/I VDD VDD VSS VSS gf180mcu_fd_sc_mcu7t5v0__inv_1
XFILLER_11_165 VDD VDD VSS VSS gf180mcu_fd_sc_mcu7t5v0__fill_2
XFILLER_7_136 VDD VDD VSS VSS gf180mcu_fd_sc_mcu7t5v0__fillcap_4
Xu_core.delay_paths.u_trc1.gen_inv_stage\[29\].inv u_core.delay_paths.u_trc1.gen_inv_stage\[29\].inv/I
+ u_core.delay_paths.u_trc1.gen_inv_stage\[30\].inv/I VDD VDD VSS VSS gf180mcu_fd_sc_mcu7t5v0__inv_1
XFILLER_3_386 VDD VDD VSS VSS gf180mcu_fd_sc_mcu7t5v0__fillcap_32
XFILLER_42_290 VDD VDD VSS VSS gf180mcu_fd_sc_mcu7t5v0__fill_2
XFILLER_4_117 VDD VDD VSS VSS gf180mcu_fd_sc_mcu7t5v0__fillcap_32
XFILLER_0_378 VDD VDD VSS VSS gf180mcu_fd_sc_mcu7t5v0__fill_1
XFILLER_17_72 VDD VDD VSS VSS gf180mcu_fd_sc_mcu7t5v0__fillcap_32
X_721_ _721_/I _721_/Z VDD VDD VSS VSS gf180mcu_fd_sc_mcu7t5v0__buf_1
X_652_ _652_/D _661_/RN _665_/CLK _652_/Q VDD VDD VSS VSS gf180mcu_fd_sc_mcu7t5v0__dffrnq_1
X_583_ _583_/I _584_/B1 VDD VDD VSS VSS gf180mcu_fd_sc_mcu7t5v0__clkinv_1
XTAP_TAPCELL_ROW_3_150 VDD VSS gf180mcu_fd_sc_mcu7t5v0__filltie
XFILLER_31_205 VDD VDD VSS VSS gf180mcu_fd_sc_mcu7t5v0__fillcap_4
Xu_core.delay_paths.u_trc0.gen_inv_stage\[164\].inv u_core.delay_paths.u_trc0.gen_inv_stage\[164\].inv/I
+ u_core.delay_paths.u_trc0.gen_inv_stage\[165\].inv/I VDD VDD VSS VSS gf180mcu_fd_sc_mcu7t5v0__inv_1
XTAP_TAPCELL_ROW_26_285 VDD VSS gf180mcu_fd_sc_mcu7t5v0__filltie
Xu_core.delay_paths.u_trc0.gen_inv_stage\[179\].inv u_core.delay_paths.u_trc0.gen_inv_stage\[179\].inv/I
+ u_core.delay_paths.u_trc0.gen_inv_stage\[180\].inv/I VDD VDD VSS VSS gf180mcu_fd_sc_mcu7t5v0__inv_1
Xu_core.delay_paths.u_trc0.gen_inv_stage\[102\].inv u_core.delay_paths.u_trc0.gen_inv_stage\[102\].inv/I
+ u_core.delay_paths.u_trc0.gen_inv_stage\[103\].inv/I VDD VDD VSS VSS gf180mcu_fd_sc_mcu7t5v0__inv_2
XFILLER_39_349 VDD VDD VSS VSS gf180mcu_fd_sc_mcu7t5v0__fill_1
XFILLER_3_194 VDD VDD VSS VSS gf180mcu_fd_sc_mcu7t5v0__fill_2
Xu_core.delay_paths.u_trc0.gen_inv_stage\[117\].inv u_core.delay_paths.u_trc0.gen_inv_stage\[117\].inv/I
+ u_core.delay_paths.u_trc0.gen_inv_stage\[118\].inv/I VDD VDD VSS VSS gf180mcu_fd_sc_mcu7t5v0__inv_2
XFILLER_22_205 VDD VDD VSS VSS gf180mcu_fd_sc_mcu7t5v0__fillcap_4
XTAP_TAPCELL_ROW_17_230 VDD VSS gf180mcu_fd_sc_mcu7t5v0__filltie
XPHY_EDGE_ROW_8_Right_8 VDD VSS gf180mcu_fd_sc_mcu7t5v0__endcap
XPHY_EDGE_ROW_29_Left_90 VDD VSS gf180mcu_fd_sc_mcu7t5v0__endcap
XPHY_EDGE_ROW_39_Right_39 VDD VSS gf180mcu_fd_sc_mcu7t5v0__endcap
XPHY_EDGE_ROW_13_Left_74 VDD VSS gf180mcu_fd_sc_mcu7t5v0__endcap
XFILLER_54_37 VDD VDD VSS VSS gf180mcu_fd_sc_mcu7t5v0__fillcap_64
Xu_core.delay_paths.u_trc0.gen_inv_stage\[53\].inv u_core.delay_paths.u_trc0.gen_inv_stage\[53\].inv/I
+ u_core.delay_paths.u_trc0.gen_inv_stage\[54\].inv/I VDD VDD VSS VSS gf180mcu_fd_sc_mcu7t5v0__clkinv_1
Xu_core.delay_paths.u_trc0.gen_inv_stage\[68\].inv u_core.delay_paths.u_trc0.gen_inv_stage\[68\].inv/I
+ u_core.delay_paths.u_trc0.gen_inv_stage\[69\].inv/I VDD VDD VSS VSS gf180mcu_fd_sc_mcu7t5v0__inv_1
XTAP_TAPCELL_ROW_0_131 VDD VSS gf180mcu_fd_sc_mcu7t5v0__filltie
XFILLER_21_282 VDD VDD VSS VSS gf180mcu_fd_sc_mcu7t5v0__fillcap_8
XFILLER_53_352 VDD VDD VSS VSS gf180mcu_fd_sc_mcu7t5v0__fillcap_64
XTAP_TAPCELL_ROW_23_266 VDD VSS gf180mcu_fd_sc_mcu7t5v0__filltie
XPHY_EDGE_ROW_48_Right_48 VDD VSS gf180mcu_fd_sc_mcu7t5v0__endcap
XFILLER_9_209 VDD VDD VSS VSS gf180mcu_fd_sc_mcu7t5v0__fill_1
XPHY_EDGE_ROW_57_Right_57 VDD VSS gf180mcu_fd_sc_mcu7t5v0__endcap
XFILLER_48_146 VDD VDD VSS VSS gf180mcu_fd_sc_mcu7t5v0__fill_1
X_704_ _704_/D _704_/RN _704_/CLK _704_/Q VDD VDD VSS VSS gf180mcu_fd_sc_mcu7t5v0__dffrnq_1
X_635_ _635_/D _687_/RN _694_/CLK _635_/Q VDD VDD VSS VSS gf180mcu_fd_sc_mcu7t5v0__dffrnq_1
X_566_ _657_/Q _566_/A2 _657_/D VDD VDD VSS VSS gf180mcu_fd_sc_mcu7t5v0__xor2_1
XFILLER_8_242 VDD VDD VSS VSS gf180mcu_fd_sc_mcu7t5v0__fill_2
X_497_ _497_/A1 _504_/S _497_/B _672_/D VDD VDD VSS VSS gf180mcu_fd_sc_mcu7t5v0__aoi21_1
XFILLER_5_42 VDD VDD VSS VSS gf180mcu_fd_sc_mcu7t5v0__fillcap_4
XFILLER_5_64 VDD VDD VSS VSS gf180mcu_fd_sc_mcu7t5v0__fill_2
XFILLER_39_168 VDD VDD VSS VSS gf180mcu_fd_sc_mcu7t5v0__fillcap_16
XFILLER_50_311 VDD VDD VSS VSS gf180mcu_fd_sc_mcu7t5v0__fillcap_4
XFILLER_2_429 VDD VDD VSS VSS gf180mcu_fd_sc_mcu7t5v0__fill_1
XFILLER_26_374 VDD VDD VSS VSS gf180mcu_fd_sc_mcu7t5v0__fillcap_8
X_420_ _420_/A1 _420_/A2 _421_/A1 _420_/A4 _432_/A1 VDD VDD VSS VSS gf180mcu_fd_sc_mcu7t5v0__nor4_1
X_351_ _351_/A1 _346_/B _351_/B _352_/B1 VDD VDD VSS VSS gf180mcu_fd_sc_mcu7t5v0__aoi21_1
XFILLER_5_212 VDD VDD VSS VSS gf180mcu_fd_sc_mcu7t5v0__fill_2
XFILLER_30_61 VDD VDD VSS VSS gf180mcu_fd_sc_mcu7t5v0__fill_2
XFILLER_30_72 VDD VDD VSS VSS gf180mcu_fd_sc_mcu7t5v0__fill_1
XFILLER_36_149 VDD VDD VSS VSS gf180mcu_fd_sc_mcu7t5v0__fill_1
XFILLER_49_422 VDD VDD VSS VSS gf180mcu_fd_sc_mcu7t5v0__fillcap_8
XTAP_TAPCELL_ROW_59_483 VDD VSS gf180mcu_fd_sc_mcu7t5v0__filltie
XFILLER_17_352 VDD VDD VSS VSS gf180mcu_fd_sc_mcu7t5v0__fill_2
XFILLER_17_363 VDD VDD VSS VSS gf180mcu_fd_sc_mcu7t5v0__fill_1
XFILLER_32_355 VDD VDD VSS VSS gf180mcu_fd_sc_mcu7t5v0__fill_2
XFILLER_44_182 VDD VDD VSS VSS gf180mcu_fd_sc_mcu7t5v0__fillcap_4
X_618_ _618_/D _618_/RN _626_/CLK _618_/Q VDD VDD VSS VSS gf180mcu_fd_sc_mcu7t5v0__dffrnq_1
X_549_ _699_/Q _655_/Q _550_/B VDD VDD VSS VSS gf180mcu_fd_sc_mcu7t5v0__nor2_1
XTAP_TAPCELL_ROW_42_383 VDD VSS gf180mcu_fd_sc_mcu7t5v0__filltie
Xu_core.delay_paths.u_trc3.gen_inv_stage\[44\].inv u_core.delay_paths.u_trc3.gen_inv_stage\[44\].inv/I
+ u_core.delay_paths.u_trc3.gen_inv_stage\[45\].inv/I VDD VDD VSS VSS gf180mcu_fd_sc_mcu7t5v0__inv_1
XFILLER_4_6 VDD VDD VSS VSS gf180mcu_fd_sc_mcu7t5v0__fillcap_16
XFILLER_58_241 VDD VDD VSS VSS gf180mcu_fd_sc_mcu7t5v0__fillcap_4
XFILLER_25_72 VDD VDD VSS VSS gf180mcu_fd_sc_mcu7t5v0__fillcap_8
XFILLER_26_193 VDD VDD VSS VSS gf180mcu_fd_sc_mcu7t5v0__fillcap_4
X_403_ _415_/B1 _401_/Z _421_/A1 VDD VDD VSS VSS gf180mcu_fd_sc_mcu7t5v0__nor2_1
X_334_ _635_/Q _546_/A2 _344_/A2 VDD VDD VSS VSS gf180mcu_fd_sc_mcu7t5v0__nand2_1
XTAP_TAPCELL_ROW_56_464 VDD VSS gf180mcu_fd_sc_mcu7t5v0__filltie
XPHY_EDGE_ROW_47_Left_108 VDD VSS gf180mcu_fd_sc_mcu7t5v0__endcap
XPHY_EDGE_ROW_56_Left_117 VDD VSS gf180mcu_fd_sc_mcu7t5v0__endcap
XFILLER_20_325 VDD VDD VSS VSS gf180mcu_fd_sc_mcu7t5v0__fillcap_4
XFILLER_32_174 VDD VDD VSS VSS gf180mcu_fd_sc_mcu7t5v0__fill_1
XFILLER_15_108 VDD VDD VSS VSS gf180mcu_fd_sc_mcu7t5v0__fill_2
Xclkbuf_4_13__f_iCLK clkbuf_0_iCLK/Z _703_/CLK VDD VDD VSS VSS gf180mcu_fd_sc_mcu7t5v0__clkbuf_16
XFILLER_11_347 VDD VDD VSS VSS gf180mcu_fd_sc_mcu7t5v0__fill_2
XFILLER_46_244 VDD VDD VSS VSS gf180mcu_fd_sc_mcu7t5v0__fill_1
XPHY_EDGE_ROW_1_Left_62 VDD VSS gf180mcu_fd_sc_mcu7t5v0__endcap
X_317_ _668_/Q _497_/A1 VDD VDD VSS VSS gf180mcu_fd_sc_mcu7t5v0__clkinv_1
XFILLER_6_340 VDD VDD VSS VSS gf180mcu_fd_sc_mcu7t5v0__fill_1
XFILLER_6_395 VDD VDD VSS VSS gf180mcu_fd_sc_mcu7t5v0__fillcap_4
XFILLER_28_2 VDD VDD VSS VSS gf180mcu_fd_sc_mcu7t5v0__fillcap_32
XFILLER_25_406 VDD VDD VSS VSS gf180mcu_fd_sc_mcu7t5v0__fillcap_8
XFILLER_37_266 VDD VDD VSS VSS gf180mcu_fd_sc_mcu7t5v0__fill_2
XFILLER_37_277 VDD VDD VSS VSS gf180mcu_fd_sc_mcu7t5v0__fill_2
XFILLER_52_247 VDD VDD VSS VSS gf180mcu_fd_sc_mcu7t5v0__fillcap_64
Xu_core.delay_paths.u_trc2.gen_inv_stage\[83\].inv u_core.delay_paths.u_trc2.gen_inv_stage\[83\].inv/I
+ u_core.delay_paths.u_trc2.gen_inv_stage\[84\].inv/I VDD VDD VSS VSS gf180mcu_fd_sc_mcu7t5v0__inv_1
XFILLER_20_177 VDD VDD VSS VSS gf180mcu_fd_sc_mcu7t5v0__fill_2
Xu_core.delay_paths.u_trc2.gen_inv_stage\[21\].inv u_core.delay_paths.u_trc2.gen_inv_stage\[21\].inv/I
+ u_core.delay_paths.u_trc2.gen_inv_stage\[22\].inv/I VDD VDD VSS VSS gf180mcu_fd_sc_mcu7t5v0__inv_1
Xu_core.delay_paths.u_trc2.gen_inv_stage\[36\].inv u_core.delay_paths.u_trc2.gen_inv_stage\[36\].inv/I
+ u_core.delay_paths.u_trc2.gen_inv_stage\[37\].inv/I VDD VDD VSS VSS gf180mcu_fd_sc_mcu7t5v0__inv_1
XFILLER_11_144 VDD VDD VSS VSS gf180mcu_fd_sc_mcu7t5v0__fill_1
XFILLER_7_104 VDD VDD VSS VSS gf180mcu_fd_sc_mcu7t5v0__fillcap_8
XFILLER_3_332 VDD VDD VSS VSS gf180mcu_fd_sc_mcu7t5v0__fillcap_16
XFILLER_3_376 VDD VDD VSS VSS gf180mcu_fd_sc_mcu7t5v0__fill_2
Xu_core.delay_paths.u_trc1.gen_inv_stage\[123\].inv u_core.delay_paths.u_trc1.gen_inv_stage\[123\].inv/I
+ u_core.delay_paths.u_trc1.gen_inv_stage\[124\].inv/I VDD VDD VSS VSS gf180mcu_fd_sc_mcu7t5v0__inv_1
Xu_core.delay_paths.u_trc1.gen_inv_stage\[138\].inv u_core.delay_paths.u_trc1.gen_inv_stage\[138\].inv/I
+ u_core.delay_paths.u_trc1.gen_inv_stage\[139\].inv/I VDD VDD VSS VSS gf180mcu_fd_sc_mcu7t5v0__inv_1
XFILLER_4_107 VDD VDD VSS VSS gf180mcu_fd_sc_mcu7t5v0__fillcap_4
XFILLER_48_317 VDD VDD VSS VSS gf180mcu_fd_sc_mcu7t5v0__fillcap_64
X_720_ _720_/I _720_/Z VDD VDD VSS VSS gf180mcu_fd_sc_mcu7t5v0__buf_1
X_651_ _651_/D _700_/RN _665_/CLK _651_/Q VDD VDD VSS VSS gf180mcu_fd_sc_mcu7t5v0__dffrnq_1
X_582_ _582_/A1 _582_/A2 _583_/I VDD VDD VSS VSS gf180mcu_fd_sc_mcu7t5v0__nand2_1
XTAP_TAPCELL_ROW_3_151 VDD VSS gf180mcu_fd_sc_mcu7t5v0__filltie
XTAP_TAPCELL_ROW_26_286 VDD VSS gf180mcu_fd_sc_mcu7t5v0__filltie
Xu_core.delay_paths.u_trc1.gen_inv_stage\[60\].inv u_core.delay_paths.u_trc1.gen_inv_stage\[60\].inv/I
+ u_core.delay_paths.u_trc1.gen_inv_stage\[61\].inv/I VDD VDD VSS VSS gf180mcu_fd_sc_mcu7t5v0__inv_1
XTAP_TAPCELL_ROW_17_231 VDD VSS gf180mcu_fd_sc_mcu7t5v0__filltie
Xu_core.delay_paths.u_trc1.gen_inv_stage\[75\].inv u_core.delay_paths.u_trc1.gen_inv_stage\[75\].inv/I
+ u_core.delay_paths.u_trc1.gen_inv_stage\[76\].inv/I VDD VDD VSS VSS gf180mcu_fd_sc_mcu7t5v0__inv_1
Xu_core.delay_paths.u_trc1.gen_inv_stage\[13\].inv u_core.delay_paths.u_trc1.gen_inv_stage\[13\].inv/I
+ u_core.delay_paths.u_trc1.gen_inv_stage\[14\].inv/I VDD VDD VSS VSS gf180mcu_fd_sc_mcu7t5v0__inv_1
XFILLER_57_136 VDD VDD VSS VSS gf180mcu_fd_sc_mcu7t5v0__fillcap_4
Xu_core.delay_paths.u_trc1.gen_inv_stage\[28\].inv u_core.delay_paths.u_trc1.gen_inv_stage\[28\].inv/I
+ u_core.delay_paths.u_trc1.gen_inv_stage\[29\].inv/I VDD VDD VSS VSS gf180mcu_fd_sc_mcu7t5v0__inv_1
XTAP_TAPCELL_ROW_0_132 VDD VSS gf180mcu_fd_sc_mcu7t5v0__filltie
XFILLER_21_294 VDD VDD VSS VSS gf180mcu_fd_sc_mcu7t5v0__fill_2
XTAP_TAPCELL_ROW_23_267 VDD VSS gf180mcu_fd_sc_mcu7t5v0__filltie
XFILLER_0_110 VDD VDD VSS VSS gf180mcu_fd_sc_mcu7t5v0__fill_2
XFILLER_0_132 VDD VDD VSS VSS gf180mcu_fd_sc_mcu7t5v0__fillcap_4
XFILLER_0_176 VDD VDD VSS VSS gf180mcu_fd_sc_mcu7t5v0__fillcap_16
XFILLER_28_72 VDD VDD VSS VSS gf180mcu_fd_sc_mcu7t5v0__fill_2
X_703_ _703_/D _705_/RN _703_/CLK _703_/Q VDD VDD VSS VSS gf180mcu_fd_sc_mcu7t5v0__dffrnq_1
X_634_ _634_/D _704_/RN _704_/CLK _634_/Q VDD VDD VSS VSS gf180mcu_fd_sc_mcu7t5v0__dffrnq_1
X_565_ _697_/Q _565_/A2 _560_/Z _565_/B2 _565_/C _566_/A2 VDD VDD VSS VSS gf180mcu_fd_sc_mcu7t5v0__aoi221_1
X_496_ _672_/Q _504_/S _497_/B VDD VDD VSS VSS gf180mcu_fd_sc_mcu7t5v0__nor2_1
XTAP_TAPCELL_ROW_14_212 VDD VSS gf180mcu_fd_sc_mcu7t5v0__filltie
XFILLER_60_70 VDD VDD VSS VSS gf180mcu_fd_sc_mcu7t5v0__fillcap_32
XFILLER_8_287 VDD VDD VSS VSS gf180mcu_fd_sc_mcu7t5v0__fillcap_16
XPHY_EDGE_ROW_30_Left_91 VDD VSS gf180mcu_fd_sc_mcu7t5v0__endcap
XFILLER_10_2 VDD VDD VSS VSS gf180mcu_fd_sc_mcu7t5v0__fillcap_32
XTAP_TAPCELL_ROW_20_248 VDD VSS gf180mcu_fd_sc_mcu7t5v0__filltie
Xu_core.delay_paths.u_trc0.gen_inv_stage\[163\].inv u_core.delay_paths.u_trc0.gen_inv_stage\[163\].inv/I
+ u_core.delay_paths.u_trc0.gen_inv_stage\[164\].inv/I VDD VDD VSS VSS gf180mcu_fd_sc_mcu7t5v0__inv_1
XFILLER_26_397 VDD VDD VSS VSS gf180mcu_fd_sc_mcu7t5v0__fillcap_16
Xu_core.delay_paths.u_trc0.gen_inv_stage\[178\].inv u_core.delay_paths.u_trc0.gen_inv_stage\[178\].inv/I
+ u_core.delay_paths.u_trc0.gen_inv_stage\[179\].inv/I VDD VDD VSS VSS gf180mcu_fd_sc_mcu7t5v0__inv_1
Xu_core.delay_paths.u_trc0.gen_inv_stage\[101\].inv u_core.delay_paths.u_trc0.gen_inv_stage\[101\].inv/I
+ u_core.delay_paths.u_trc0.gen_inv_stage\[102\].inv/I VDD VDD VSS VSS gf180mcu_fd_sc_mcu7t5v0__inv_2
X_350_ _350_/A1 _350_/A2 _351_/B _352_/A2 VDD VDD VSS VSS gf180mcu_fd_sc_mcu7t5v0__oai21_1
XFILLER_5_224 VDD VDD VSS VSS gf180mcu_fd_sc_mcu7t5v0__fill_2
Xu_core.delay_paths.u_trc0.gen_inv_stage\[116\].inv u_core.delay_paths.u_trc0.gen_inv_stage\[116\].inv/I
+ u_core.delay_paths.u_trc0.gen_inv_stage\[117\].inv/I VDD VDD VSS VSS gf180mcu_fd_sc_mcu7t5v0__inv_2
X_617_ _617_/D _617_/RN _626_/CLK _618_/D VDD VDD VSS VSS gf180mcu_fd_sc_mcu7t5v0__dffrnq_1
XTAP_TAPCELL_ROW_59_484 VDD VSS gf180mcu_fd_sc_mcu7t5v0__filltie
Xu_core.delay_paths.u_trc0.gen_inv_stage\[52\].inv u_core.delay_paths.u_trc0.gen_inv_stage\[52\].inv/I
+ u_core.delay_paths.u_trc0.gen_inv_stage\[53\].inv/I VDD VDD VSS VSS gf180mcu_fd_sc_mcu7t5v0__inv_1
X_548_ _579_/A1 _699_/Q _548_/B _654_/D VDD VDD VSS VSS gf180mcu_fd_sc_mcu7t5v0__aoi21_1
X_479_ _668_/Q _667_/Q _669_/Q _670_/Q _492_/A2 VDD VDD VSS VSS gf180mcu_fd_sc_mcu7t5v0__nand4_1
XTAP_TAPCELL_ROW_42_384 VDD VSS gf180mcu_fd_sc_mcu7t5v0__filltie
XFILLER_58_2 VDD VDD VSS VSS gf180mcu_fd_sc_mcu7t5v0__fillcap_32
Xu_core.delay_paths.u_trc0.gen_inv_stage\[67\].inv u_core.delay_paths.u_trc0.gen_inv_stage\[67\].inv/I
+ u_core.delay_paths.u_trc0.gen_inv_stage\[68\].inv/I VDD VDD VSS VSS gf180mcu_fd_sc_mcu7t5v0__inv_1
XFILLER_23_323 VDD VDD VSS VSS gf180mcu_fd_sc_mcu7t5v0__fillcap_8
XFILLER_42_109 VDD VDD VSS VSS gf180mcu_fd_sc_mcu7t5v0__fill_1
XFILLER_18_139 VDD VDD VSS VSS gf180mcu_fd_sc_mcu7t5v0__fillcap_16
XTAP_TAPCELL_ROW_56_465 VDD VSS gf180mcu_fd_sc_mcu7t5v0__filltie
XFILLER_14_312 VDD VDD VSS VSS gf180mcu_fd_sc_mcu7t5v0__fill_2
XFILLER_41_142 VDD VDD VSS VSS gf180mcu_fd_sc_mcu7t5v0__fill_1
X_402_ _686_/Q _402_/A2 _416_/B2 VDD VDD VSS VSS gf180mcu_fd_sc_mcu7t5v0__xnor2_1
X_333_ _333_/I _338_/B VDD VDD VSS VSS gf180mcu_fd_sc_mcu7t5v0__clkinv_1
XFILLER_41_50 VDD VDD VSS VSS gf180mcu_fd_sc_mcu7t5v0__fill_1
XFILLER_41_72 VDD VDD VSS VSS gf180mcu_fd_sc_mcu7t5v0__fillcap_4
XFILLER_1_260 VDD VDD VSS VSS gf180mcu_fd_sc_mcu7t5v0__fillcap_8
XFILLER_52_429 VDD VDD VSS VSS gf180mcu_fd_sc_mcu7t5v0__fill_1
XTAP_TAPCELL_ROW_47_410 VDD VSS gf180mcu_fd_sc_mcu7t5v0__filltie
XTAP_TAPCELL_ROW_30_310 VDD VSS gf180mcu_fd_sc_mcu7t5v0__filltie
XFILLER_55_212 VDD VDD VSS VSS gf180mcu_fd_sc_mcu7t5v0__fillcap_64
Xmax_cap18 _448_/B1 _535_/A2 VDD VDD VSS VSS gf180mcu_fd_sc_mcu7t5v0__buf_2
XTAP_TAPCELL_ROW_53_446 VDD VSS gf180mcu_fd_sc_mcu7t5v0__filltie
XFILLER_19_426 VDD VDD VSS VSS gf180mcu_fd_sc_mcu7t5v0__fillcap_4
XFILLER_46_201 VDD VDD VSS VSS gf180mcu_fd_sc_mcu7t5v0__fillcap_4
X_316_ _316_/I _480_/A1 VDD VDD VSS VSS gf180mcu_fd_sc_mcu7t5v0__clkinv_1
XFILLER_6_374 VDD VDD VSS VSS gf180mcu_fd_sc_mcu7t5v0__fillcap_4
XFILLER_37_212 VDD VDD VSS VSS gf180mcu_fd_sc_mcu7t5v0__fillcap_4
Xu_core.delay_paths.u_trc3.gen_inv_stage\[43\].inv u_core.delay_paths.u_trc3.gen_inv_stage\[43\].inv/I
+ u_core.delay_paths.u_trc3.gen_inv_stage\[44\].inv/I VDD VDD VSS VSS gf180mcu_fd_sc_mcu7t5v0__inv_1
XFILLER_25_418 VDD VDD VSS VSS gf180mcu_fd_sc_mcu7t5v0__fill_2
XFILLER_20_167 VDD VDD VSS VSS gf180mcu_fd_sc_mcu7t5v0__fill_2
XFILLER_9_190 VDD VDD VSS VSS gf180mcu_fd_sc_mcu7t5v0__fill_2
XFILLER_22_85 VDD VDD VSS VSS gf180mcu_fd_sc_mcu7t5v0__fillcap_4
XFILLER_3_300 VDD VDD VSS VSS gf180mcu_fd_sc_mcu7t5v0__fillcap_32
XFILLER_19_212 VDD VDD VSS VSS gf180mcu_fd_sc_mcu7t5v0__fill_2
XFILLER_42_292 VDD VDD VSS VSS gf180mcu_fd_sc_mcu7t5v0__fill_1
XFILLER_40_2 VDD VDD VSS VSS gf180mcu_fd_sc_mcu7t5v0__fillcap_32
XFILLER_6_193 VDD VDD VSS VSS gf180mcu_fd_sc_mcu7t5v0__fillcap_4
XFILLER_0_303 VDD VDD VSS VSS gf180mcu_fd_sc_mcu7t5v0__fill_2
X_650_ _650_/D _705_/RN _665_/CLK _650_/Q VDD VDD VSS VSS gf180mcu_fd_sc_mcu7t5v0__dffrnq_1
XFILLER_12_421 VDD VDD VSS VSS gf180mcu_fd_sc_mcu7t5v0__fillcap_8
XFILLER_16_226 VDD VDD VSS VSS gf180mcu_fd_sc_mcu7t5v0__fill_2
X_581_ _581_/A1 _658_/Q _659_/Q _660_/Q _582_/A2 VDD VDD VSS VSS gf180mcu_fd_sc_mcu7t5v0__nand4_1
XTAP_TAPCELL_ROW_26_287 VDD VSS gf180mcu_fd_sc_mcu7t5v0__filltie
XFILLER_3_174 VDD VDD VSS VSS gf180mcu_fd_sc_mcu7t5v0__fillcap_16
Xu_core.delay_paths.u_trc2.gen_inv_stage\[82\].inv u_core.delay_paths.u_trc2.gen_inv_stage\[82\].inv/I
+ u_core.delay_paths.u_trc2.gen_inv_stage\[83\].inv/I VDD VDD VSS VSS gf180mcu_fd_sc_mcu7t5v0__inv_1
Xu_core.delay_paths.u_trc2.gen_inv_stage\[20\].inv u_core.delay_paths.u_trc2.gen_inv_stage\[20\].inv/I
+ u_core.delay_paths.u_trc2.gen_inv_stage\[21\].inv/I VDD VDD VSS VSS gf180mcu_fd_sc_mcu7t5v0__inv_1
XFILLER_30_262 VDD VDD VSS VSS gf180mcu_fd_sc_mcu7t5v0__fill_1
Xu_core.delay_paths.u_trc2.gen_inv_stage\[35\].inv u_core.delay_paths.u_trc2.gen_inv_stage\[35\].inv/I
+ u_core.delay_paths.u_trc2.gen_inv_stage\[36\].inv/I VDD VDD VSS VSS gf180mcu_fd_sc_mcu7t5v0__inv_1
XTAP_TAPCELL_ROW_17_232 VDD VSS gf180mcu_fd_sc_mcu7t5v0__filltie
XFILLER_38_373 VDD VDD VSS VSS gf180mcu_fd_sc_mcu7t5v0__fillcap_8
XTAP_TAPCELL_ROW_0_133 VDD VSS gf180mcu_fd_sc_mcu7t5v0__filltie
XTAP_TAPCELL_ROW_0_122 VDD VSS gf180mcu_fd_sc_mcu7t5v0__filltie
XFILLER_21_273 VDD VDD VSS VSS gf180mcu_fd_sc_mcu7t5v0__fillcap_4
XFILLER_5_406 VDD VDD VSS VSS gf180mcu_fd_sc_mcu7t5v0__fillcap_8
XTAP_TAPCELL_ROW_23_268 VDD VSS gf180mcu_fd_sc_mcu7t5v0__filltie
XFILLER_0_155 VDD VDD VSS VSS gf180mcu_fd_sc_mcu7t5v0__fill_1
X_702_ _702_/D _702_/RN _702_/CLK _702_/Q VDD VDD VSS VSS gf180mcu_fd_sc_mcu7t5v0__dffrnq_1
X_633_ _633_/D _633_/RN _615_/CLK _633_/Q VDD VDD VSS VSS gf180mcu_fd_sc_mcu7t5v0__dffnrnq_1
XFILLER_44_387 VDD VDD VSS VSS gf180mcu_fd_sc_mcu7t5v0__fillcap_32
XFILLER_44_83 VDD VDD VSS VSS gf180mcu_fd_sc_mcu7t5v0__fillcap_8
Xu_core.delay_paths.u_trc1.gen_inv_stage\[122\].inv u_core.delay_paths.u_trc1.gen_inv_stage\[122\].inv/I
+ u_core.delay_paths.u_trc1.gen_inv_stage\[123\].inv/I VDD VDD VSS VSS gf180mcu_fd_sc_mcu7t5v0__inv_1
X_564_ _581_/A1 _656_/Q _565_/B2 VDD VDD VSS VSS gf180mcu_fd_sc_mcu7t5v0__nand2_1
X_495_ _671_/Q _667_/Q _515_/S _671_/D VDD VDD VSS VSS gf180mcu_fd_sc_mcu7t5v0__mux2_2
XTAP_TAPCELL_ROW_14_213 VDD VSS gf180mcu_fd_sc_mcu7t5v0__filltie
XFILLER_8_244 VDD VDD VSS VSS gf180mcu_fd_sc_mcu7t5v0__fill_1
Xu_core.delay_paths.u_trc1.gen_inv_stage\[137\].inv u_core.delay_paths.u_trc1.gen_inv_stage\[137\].inv/I
+ u_core.delay_paths.u_trc1.gen_inv_stage\[138\].inv/I VDD VDD VSS VSS gf180mcu_fd_sc_mcu7t5v0__inv_1
XFILLER_39_137 VDD VDD VSS VSS gf180mcu_fd_sc_mcu7t5v0__fill_2
XFILLER_35_332 VDD VDD VSS VSS gf180mcu_fd_sc_mcu7t5v0__fillcap_8
XFILLER_54_107 VDD VDD VSS VSS gf180mcu_fd_sc_mcu7t5v0__fillcap_64
XTAP_TAPCELL_ROW_20_249 VDD VSS gf180mcu_fd_sc_mcu7t5v0__filltie
XFILLER_41_313 VDD VDD VSS VSS gf180mcu_fd_sc_mcu7t5v0__fillcap_8
XFILLER_5_258 VDD VDD VSS VSS gf180mcu_fd_sc_mcu7t5v0__fill_2
Xu_core.delay_paths.u_trc1.gen_inv_stage\[74\].inv u_core.delay_paths.u_trc1.gen_inv_stage\[74\].inv/I
+ u_core.delay_paths.u_trc1.gen_inv_stage\[75\].inv/I VDD VDD VSS VSS gf180mcu_fd_sc_mcu7t5v0__inv_1
XFILLER_29_181 VDD VDD VSS VSS gf180mcu_fd_sc_mcu7t5v0__fillcap_4
XFILLER_36_107 VDD VDD VSS VSS gf180mcu_fd_sc_mcu7t5v0__fillcap_8
Xu_core.delay_paths.u_trc1.gen_inv_stage\[89\].inv u_core.delay_paths.u_trc1.gen_inv_stage\[89\].inv/I
+ u_core.delay_paths.u_trc1.gen_inv_stage\[90\].inv/I VDD VDD VSS VSS gf180mcu_fd_sc_mcu7t5v0__inv_1
X_616_ _616_/D _616_/RN _626_/CLK _617_/D VDD VDD VSS VSS gf180mcu_fd_sc_mcu7t5v0__dffrnq_1
X_547_ _547_/A1 _654_/Q _548_/B VDD VDD VSS VSS gf180mcu_fd_sc_mcu7t5v0__nor2_1
XTAP_TAPCELL_ROW_59_485 VDD VSS gf180mcu_fd_sc_mcu7t5v0__filltie
XFILLER_32_357 VDD VDD VSS VSS gf180mcu_fd_sc_mcu7t5v0__fill_1
Xu_core.delay_paths.u_trc1.gen_inv_stage\[12\].inv u_core.delay_paths.u_trc1.gen_inv_stage\[12\].inv/I
+ u_core.delay_paths.u_trc1.gen_inv_stage\[13\].inv/I VDD VDD VSS VSS gf180mcu_fd_sc_mcu7t5v0__inv_1
X_478_ _668_/Q _667_/Q _486_/A2 VDD VDD VSS VSS gf180mcu_fd_sc_mcu7t5v0__nand2_1
XTAP_TAPCELL_ROW_42_385 VDD VSS gf180mcu_fd_sc_mcu7t5v0__filltie
Xu_core.delay_paths.u_trc1.gen_inv_stage\[27\].inv u_core.delay_paths.u_trc1.gen_inv_stage\[27\].inv/I
+ u_core.delay_paths.u_trc1.gen_inv_stage\[28\].inv/I VDD VDD VSS VSS gf180mcu_fd_sc_mcu7t5v0__inv_1
XFILLER_55_416 VDD VDD VSS VSS gf180mcu_fd_sc_mcu7t5v0__fillcap_4
XFILLER_23_346 VDD VDD VSS VSS gf180mcu_fd_sc_mcu7t5v0__fillcap_4
XTAP_TAPCELL_ROW_33_330 VDD VSS gf180mcu_fd_sc_mcu7t5v0__filltie
XFILLER_18_107 VDD VDD VSS VSS gf180mcu_fd_sc_mcu7t5v0__fillcap_32
XFILLER_46_427 VDD VDD VSS VSS gf180mcu_fd_sc_mcu7t5v0__fill_2
X_401_ _686_/Q _402_/A2 _401_/Z VDD VDD VSS VSS gf180mcu_fd_sc_mcu7t5v0__xor2_1
XTAP_TAPCELL_ROW_56_466 VDD VSS gf180mcu_fd_sc_mcu7t5v0__filltie
X_332_ _654_/Q _636_/Q _333_/I VDD VDD VSS VSS gf180mcu_fd_sc_mcu7t5v0__xnor2_1
XFILLER_2_34 VDD VDD VSS VSS gf180mcu_fd_sc_mcu7t5v0__fill_1
XFILLER_37_416 VDD VDD VSS VSS gf180mcu_fd_sc_mcu7t5v0__fillcap_4
XFILLER_49_276 VDD VDD VSS VSS gf180mcu_fd_sc_mcu7t5v0__fillcap_4
XTAP_TAPCELL_ROW_47_411 VDD VSS gf180mcu_fd_sc_mcu7t5v0__filltie
XFILLER_17_184 VDD VDD VSS VSS gf180mcu_fd_sc_mcu7t5v0__fillcap_4
XFILLER_52_419 VDD VDD VSS VSS gf180mcu_fd_sc_mcu7t5v0__fillcap_8
Xu_core.delay_paths.u_trc0.gen_inv_stage\[162\].inv u_core.delay_paths.u_trc0.gen_inv_stage\[162\].inv/I
+ u_core.delay_paths.u_trc0.gen_inv_stage\[163\].inv/I VDD VDD VSS VSS gf180mcu_fd_sc_mcu7t5v0__inv_1
XTAP_TAPCELL_ROW_30_311 VDD VSS gf180mcu_fd_sc_mcu7t5v0__filltie
Xu_core.delay_paths.u_trc0.gen_inv_stage\[177\].inv u_core.delay_paths.u_trc0.gen_inv_stage\[177\].inv/I
+ u_core.delay_paths.u_trc0.gen_inv_stage\[178\].inv/I VDD VDD VSS VSS gf180mcu_fd_sc_mcu7t5v0__inv_1
Xu_core.delay_paths.u_trc0.gen_inv_stage\[100\].inv u_core.delay_paths.u_trc0.gen_inv_stage\[99\].inv/ZN
+ u_core.delay_paths.u_trc0.gen_inv_stage\[101\].inv/I VDD VDD VSS VSS gf180mcu_fd_sc_mcu7t5v0__inv_2
XFILLER_28_427 VDD VDD VSS VSS gf180mcu_fd_sc_mcu7t5v0__fill_2
Xu_core.delay_paths.u_trc0.gen_inv_stage\[115\].inv u_core.delay_paths.u_trc0.gen_inv_stage\[115\].inv/I
+ u_core.delay_paths.u_trc0.gen_inv_stage\[116\].inv/I VDD VDD VSS VSS gf180mcu_fd_sc_mcu7t5v0__inv_2
XFILLER_11_349 VDD VDD VSS VSS gf180mcu_fd_sc_mcu7t5v0__fill_1
XFILLER_23_187 VDD VDD VSS VSS gf180mcu_fd_sc_mcu7t5v0__fillcap_8
XTAP_TAPCELL_ROW_53_447 VDD VSS gf180mcu_fd_sc_mcu7t5v0__filltie
Xu_core.delay_paths.u_trc0.gen_inv_stage\[51\].inv u_core.delay_paths.u_trc0.gen_inv_stage\[51\].inv/I
+ u_core.delay_paths.u_trc0.gen_inv_stage\[52\].inv/I VDD VDD VSS VSS gf180mcu_fd_sc_mcu7t5v0__inv_1
Xclkbuf_4_7__f_iCLK clkbuf_0_iCLK/Z _702_/CLK VDD VDD VSS VSS gf180mcu_fd_sc_mcu7t5v0__clkbuf_16
XFILLER_14_132 VDD VDD VSS VSS gf180mcu_fd_sc_mcu7t5v0__fillcap_8
Xu_core.delay_paths.u_trc0.gen_inv_stage\[66\].inv u_core.delay_paths.u_trc0.gen_inv_stage\[66\].inv/I
+ u_core.delay_paths.u_trc0.gen_inv_stage\[67\].inv/I VDD VDD VSS VSS gf180mcu_fd_sc_mcu7t5v0__inv_1
XFILLER_14_165 VDD VDD VSS VSS gf180mcu_fd_sc_mcu7t5v0__fillcap_4
XFILLER_14_198 VDD VDD VSS VSS gf180mcu_fd_sc_mcu7t5v0__fill_2
XFILLER_6_331 VDD VDD VSS VSS gf180mcu_fd_sc_mcu7t5v0__fill_1
X_315_ _315_/I _461_/B VDD VDD VSS VSS gf180mcu_fd_sc_mcu7t5v0__clkinv_1
XFILLER_6_364 VDD VDD VSS VSS gf180mcu_fd_sc_mcu7t5v0__fill_1
XFILLER_37_279 VDD VDD VSS VSS gf180mcu_fd_sc_mcu7t5v0__fill_1
Xu_core.delay_paths.u_trc0.gen_inv_stage\[19\].inv u_core.delay_paths.u_trc0.gen_inv_stage\[19\].inv/I
+ u_core.delay_paths.u_trc0.gen_inv_stage\[20\].inv/I VDD VDD VSS VSS gf180mcu_fd_sc_mcu7t5v0__inv_1
XFILLER_60_271 VDD VDD VSS VSS gf180mcu_fd_sc_mcu7t5v0__fill_1
XTAP_TAPCELL_ROW_50_428 VDD VSS gf180mcu_fd_sc_mcu7t5v0__filltie
Xwire72 wire72/I _702_/D VDD VDD VSS VSS gf180mcu_fd_sc_mcu7t5v0__buf_3
XFILLER_11_102 VDD VDD VSS VSS gf180mcu_fd_sc_mcu7t5v0__fill_2
XFILLER_51_282 VDD VDD VSS VSS gf180mcu_fd_sc_mcu7t5v0__fillcap_64
XFILLER_7_128 VDD VDD VSS VSS gf180mcu_fd_sc_mcu7t5v0__fillcap_8
XFILLER_0_2 VDD VDD VSS VSS gf180mcu_fd_sc_mcu7t5v0__fillcap_32
XFILLER_47_72 VDD VDD VSS VSS gf180mcu_fd_sc_mcu7t5v0__fillcap_8
XFILLER_33_2 VDD VDD VSS VSS gf180mcu_fd_sc_mcu7t5v0__fillcap_64
XFILLER_25_216 VDD VDD VSS VSS gf180mcu_fd_sc_mcu7t5v0__fill_2
XFILLER_0_315 VDD VDD VSS VSS gf180mcu_fd_sc_mcu7t5v0__fillcap_16
X_580_ _581_/A1 _660_/Q _556_/Z _584_/B2 _584_/A2 VDD VDD VSS VSS gf180mcu_fd_sc_mcu7t5v0__nor4_1
XFILLER_16_238 VDD VDD VSS VSS gf180mcu_fd_sc_mcu7t5v0__fillcap_4
XTAP_TAPCELL_ROW_26_288 VDD VSS gf180mcu_fd_sc_mcu7t5v0__filltie
Xu_core.delay_paths.u_trc3.gen_inv_stage\[42\].inv u_core.delay_paths.u_trc3.gen_inv_stage\[42\].inv/I
+ u_core.delay_paths.u_trc3.gen_inv_stage\[43\].inv/I VDD VDD VSS VSS gf180mcu_fd_sc_mcu7t5v0__inv_1
XFILLER_39_308 VDD VDD VSS VSS gf180mcu_fd_sc_mcu7t5v0__fillcap_8
XFILLER_3_142 VDD VDD VSS VSS gf180mcu_fd_sc_mcu7t5v0__fillcap_32
XFILLER_47_352 VDD VDD VSS VSS gf180mcu_fd_sc_mcu7t5v0__fillcap_64
XTAP_TAPCELL_ROW_17_233 VDD VSS gf180mcu_fd_sc_mcu7t5v0__filltie
XFILLER_30_230 VDD VDD VSS VSS gf180mcu_fd_sc_mcu7t5v0__fillcap_8
XTAP_TAPCELL_ROW_0_123 VDD VSS gf180mcu_fd_sc_mcu7t5v0__filltie
XFILLER_5_418 VDD VDD VSS VSS gf180mcu_fd_sc_mcu7t5v0__fill_2
XTAP_TAPCELL_ROW_23_269 VDD VSS gf180mcu_fd_sc_mcu7t5v0__filltie
XPHY_EDGE_ROW_17_Right_17 VDD VSS gf180mcu_fd_sc_mcu7t5v0__endcap
XPHY_EDGE_ROW_26_Right_26 VDD VSS gf180mcu_fd_sc_mcu7t5v0__endcap
XFILLER_28_74 VDD VDD VSS VSS gf180mcu_fd_sc_mcu7t5v0__fill_1
XFILLER_29_352 VDD VDD VSS VSS gf180mcu_fd_sc_mcu7t5v0__fillcap_16
XFILLER_56_171 VDD VDD VSS VSS gf180mcu_fd_sc_mcu7t5v0__fillcap_4
X_701_ _701_/D _702_/RN _702_/CLK _701_/Q VDD VDD VSS VSS gf180mcu_fd_sc_mcu7t5v0__dffrnq_1
X_632_ _632_/D _632_/RN _615_/CLK _632_/Q VDD VDD VSS VSS gf180mcu_fd_sc_mcu7t5v0__dffnrnq_1
X_563_ _656_/Q _563_/A2 _656_/D VDD VDD VSS VSS gf180mcu_fd_sc_mcu7t5v0__xor2_1
X_494_ _494_/A1 _494_/A2 _494_/B1 _500_/A1 _670_/D VDD VDD VSS VSS gf180mcu_fd_sc_mcu7t5v0__aoi22_1
XTAP_TAPCELL_ROW_14_214 VDD VSS gf180mcu_fd_sc_mcu7t5v0__filltie
XPHY_EDGE_ROW_35_Right_35 VDD VSS gf180mcu_fd_sc_mcu7t5v0__endcap
XFILLER_5_34 VDD VDD VSS VSS gf180mcu_fd_sc_mcu7t5v0__fillcap_8
XFILLER_8_267 VDD VDD VSS VSS gf180mcu_fd_sc_mcu7t5v0__fillcap_4
XPHY_EDGE_ROW_44_Right_44 VDD VSS gf180mcu_fd_sc_mcu7t5v0__endcap
XPHY_EDGE_ROW_53_Right_53 VDD VSS gf180mcu_fd_sc_mcu7t5v0__endcap
XPHY_EDGE_ROW_17_Left_78 VDD VSS gf180mcu_fd_sc_mcu7t5v0__endcap
XFILLER_38_193 VDD VDD VSS VSS gf180mcu_fd_sc_mcu7t5v0__fillcap_4
Xu_core.delay_paths.u_trc2.gen_inv_stage\[81\].inv u_core.delay_paths.u_trc2.gen_inv_stage\[81\].inv/I
+ u_core.delay_paths.u_trc2.gen_inv_stage\[82\].inv/I VDD VDD VSS VSS gf180mcu_fd_sc_mcu7t5v0__inv_1
XFILLER_41_325 VDD VDD VSS VSS gf180mcu_fd_sc_mcu7t5v0__fillcap_16
XFILLER_30_53 VDD VDD VSS VSS gf180mcu_fd_sc_mcu7t5v0__fillcap_8
Xu_core.delay_paths.u_trc2.gen_inv_stage\[34\].inv u_core.delay_paths.u_trc2.gen_inv_stage\[34\].inv/I
+ u_core.delay_paths.u_trc2.gen_inv_stage\[35\].inv/I VDD VDD VSS VSS gf180mcu_fd_sc_mcu7t5v0__inv_1
XFILLER_32_314 VDD VDD VSS VSS gf180mcu_fd_sc_mcu7t5v0__fill_1
XFILLER_36_119 VDD VDD VSS VSS gf180mcu_fd_sc_mcu7t5v0__fill_1
XFILLER_55_72 VDD VDD VSS VSS gf180mcu_fd_sc_mcu7t5v0__fillcap_64
Xu_core.delay_paths.u_trc2.gen_inv_stage\[49\].inv u_core.delay_paths.u_trc2.gen_inv_stage\[49\].inv/I
+ u_core.delay_paths.u_trc2.gen_inv_stage\[50\].inv/I VDD VDD VSS VSS gf180mcu_fd_sc_mcu7t5v0__inv_1
X_615_ _615_/D _615_/RN _615_/CLK _616_/D VDD VDD VSS VSS gf180mcu_fd_sc_mcu7t5v0__dffrnq_1
X_546_ _547_/A1 _546_/A2 _546_/B _653_/D VDD VDD VSS VSS gf180mcu_fd_sc_mcu7t5v0__oai21_1
XTAP_TAPCELL_ROW_59_486 VDD VSS gf180mcu_fd_sc_mcu7t5v0__filltie
X_477_ _466_/Z _477_/A2 _666_/D VDD VDD VSS VSS gf180mcu_fd_sc_mcu7t5v0__nor2_1
XFILLER_50_177 VDD VDD VSS VSS gf180mcu_fd_sc_mcu7t5v0__fillcap_64
XTAP_TAPCELL_ROW_33_331 VDD VSS gf180mcu_fd_sc_mcu7t5v0__filltie
Xu_core.delay_paths.u_trc1.gen_inv_stage\[121\].inv u_core.delay_paths.u_trc1.gen_inv_stage\[121\].inv/I
+ u_core.delay_paths.u_trc1.gen_inv_stage\[122\].inv/I VDD VDD VSS VSS gf180mcu_fd_sc_mcu7t5v0__inv_1
XFILLER_14_314 VDD VDD VSS VSS gf180mcu_fd_sc_mcu7t5v0__fill_1
Xu_core.delay_paths.u_trc1.gen_inv_stage\[136\].inv u_core.delay_paths.u_trc1.gen_inv_stage\[136\].inv/I
+ u_core.delay_paths.u_trc1.gen_inv_stage\[137\].inv/I VDD VDD VSS VSS gf180mcu_fd_sc_mcu7t5v0__inv_1
X_400_ _514_/A1 _400_/A2 _400_/B _415_/B1 VDD VDD VSS VSS gf180mcu_fd_sc_mcu7t5v0__oai21_1
X_331_ _654_/Q _525_/A1 _350_/A1 VDD VDD VSS VSS gf180mcu_fd_sc_mcu7t5v0__nor2_1
XTAP_TAPCELL_ROW_56_467 VDD VSS gf180mcu_fd_sc_mcu7t5v0__filltie
XFILLER_22_391 VDD VDD VSS VSS gf180mcu_fd_sc_mcu7t5v0__fill_2
XFILLER_41_166 VDD VDD VSS VSS gf180mcu_fd_sc_mcu7t5v0__fillcap_4
Xclkbuf_4_3__f_iCLK clkbuf_0_iCLK/Z _665_/CLK VDD VDD VSS VSS gf180mcu_fd_sc_mcu7t5v0__clkbuf_16
XTAP_TAPCELL_ROW_47_412 VDD VSS gf180mcu_fd_sc_mcu7t5v0__filltie
XFILLER_20_317 VDD VDD VSS VSS gf180mcu_fd_sc_mcu7t5v0__fillcap_8
XFILLER_32_111 VDD VDD VSS VSS gf180mcu_fd_sc_mcu7t5v0__fill_1
XFILLER_32_155 VDD VDD VSS VSS gf180mcu_fd_sc_mcu7t5v0__fill_2
XFILLER_32_166 VDD VDD VSS VSS gf180mcu_fd_sc_mcu7t5v0__fillcap_8
XFILLER_32_177 VDD VDD VSS VSS gf180mcu_fd_sc_mcu7t5v0__fill_1
XFILLER_32_188 VDD VDD VSS VSS gf180mcu_fd_sc_mcu7t5v0__fillcap_16
X_529_ _639_/Q _528_/S _639_/D VDD VDD VSS VSS gf180mcu_fd_sc_mcu7t5v0__and2_1
XTAP_TAPCELL_ROW_30_312 VDD VSS gf180mcu_fd_sc_mcu7t5v0__filltie
XTAP_TAPCELL_ROW_53_448 VDD VSS gf180mcu_fd_sc_mcu7t5v0__filltie
XPHY_EDGE_ROW_43_Left_104 VDD VSS gf180mcu_fd_sc_mcu7t5v0__endcap
XFILLER_23_155 VDD VDD VSS VSS gf180mcu_fd_sc_mcu7t5v0__fillcap_32
Xu_core.delay_paths.u_trc1.gen_inv_stage\[73\].inv u_core.delay_paths.u_trc1.gen_inv_stage\[73\].inv/I
+ u_core.delay_paths.u_trc1.gen_inv_stage\[74\].inv/I VDD VDD VSS VSS gf180mcu_fd_sc_mcu7t5v0__inv_1
XFILLER_11_66 VDD VDD VSS VSS gf180mcu_fd_sc_mcu7t5v0__fillcap_4
Xu_core.delay_paths.u_trc1.gen_inv_stage\[88\].inv u_core.delay_paths.u_trc1.gen_inv_stage\[88\].inv/I
+ u_core.delay_paths.u_trc1.gen_inv_stage\[89\].inv/I VDD VDD VSS VSS gf180mcu_fd_sc_mcu7t5v0__inv_1
XPHY_EDGE_ROW_52_Left_113 VDD VSS gf180mcu_fd_sc_mcu7t5v0__endcap
XFILLER_46_247 VDD VDD VSS VSS gf180mcu_fd_sc_mcu7t5v0__fillcap_64
Xu_core.delay_paths.u_trc1.gen_inv_stage\[11\].inv u_core.delay_paths.u_trc1.gen_inv_stage\[11\].inv/I
+ u_core.delay_paths.u_trc1.gen_inv_stage\[12\].inv/I VDD VDD VSS VSS gf180mcu_fd_sc_mcu7t5v0__inv_1
XFILLER_14_144 VDD VDD VSS VSS gf180mcu_fd_sc_mcu7t5v0__fill_2
XFILLER_14_177 VDD VDD VSS VSS gf180mcu_fd_sc_mcu7t5v0__fill_2
Xu_core.delay_paths.u_trc1.gen_inv_stage\[26\].inv u_core.delay_paths.u_trc1.gen_inv_stage\[26\].inv/I
+ u_core.delay_paths.u_trc1.gen_inv_stage\[27\].inv/I VDD VDD VSS VSS gf180mcu_fd_sc_mcu7t5v0__inv_1
X_314_ _605_/Q _461_/A1 VDD VDD VSS VSS gf180mcu_fd_sc_mcu7t5v0__clkinv_1
XFILLER_10_372 VDD VDD VSS VSS gf180mcu_fd_sc_mcu7t5v0__fill_2
XFILLER_6_310 VDD VDD VSS VSS gf180mcu_fd_sc_mcu7t5v0__fill_1
XFILLER_6_387 VDD VDD VSS VSS gf180mcu_fd_sc_mcu7t5v0__fillcap_8
XFILLER_20_147 VDD VDD VSS VSS gf180mcu_fd_sc_mcu7t5v0__fillcap_16
XTAP_TAPCELL_ROW_50_429 VDD VSS gf180mcu_fd_sc_mcu7t5v0__filltie
XFILLER_9_192 VDD VDD VSS VSS gf180mcu_fd_sc_mcu7t5v0__fill_1
XFILLER_43_206 VDD VDD VSS VSS gf180mcu_fd_sc_mcu7t5v0__fillcap_4
XFILLER_3_368 VDD VDD VSS VSS gf180mcu_fd_sc_mcu7t5v0__fillcap_8
XPHY_EDGE_ROW_5_Left_66 VDD VSS gf180mcu_fd_sc_mcu7t5v0__endcap
XFILLER_19_214 VDD VDD VSS VSS gf180mcu_fd_sc_mcu7t5v0__fill_1
Xu_core.delay_paths.u_trc0.gen_inv_stage\[176\].inv u_core.delay_paths.u_trc0.gen_inv_stage\[176\].inv/I
+ u_core.delay_paths.u_trc0.gen_inv_stage\[177\].inv/I VDD VDD VSS VSS gf180mcu_fd_sc_mcu7t5v0__inv_1
Xu_core.delay_paths.u_trc0.gen_inv_stage\[161\].inv u_core.delay_paths.u_trc0.gen_inv_stage\[161\].inv/I
+ u_core.delay_paths.u_trc0.gen_inv_stage\[162\].inv/I VDD VDD VSS VSS gf180mcu_fd_sc_mcu7t5v0__inv_1
XFILLER_8_34 VDD VDD VSS VSS gf180mcu_fd_sc_mcu7t5v0__fill_1
XFILLER_10_191 VDD VDD VSS VSS gf180mcu_fd_sc_mcu7t5v0__fill_1
XFILLER_6_173 VDD VDD VSS VSS gf180mcu_fd_sc_mcu7t5v0__fill_2
Xu_core.delay_paths.u_trc0.gen_inv_stage\[114\].inv u_core.delay_paths.u_trc0.gen_inv_stage\[114\].inv/I
+ u_core.delay_paths.u_trc0.gen_inv_stage\[115\].inv/I VDD VDD VSS VSS gf180mcu_fd_sc_mcu7t5v0__inv_2
XFILLER_26_2 VDD VDD VSS VSS gf180mcu_fd_sc_mcu7t5v0__fillcap_32
Xu_core.delay_paths.u_trc0.gen_inv_stage\[129\].inv u_core.delay_paths.u_trc0.gen_inv_stage\[129\].inv/I
+ u_core.delay_paths.u_trc0.gen_inv_stage\[130\].inv/I VDD VDD VSS VSS gf180mcu_fd_sc_mcu7t5v0__inv_1
XFILLER_33_250 VDD VDD VSS VSS gf180mcu_fd_sc_mcu7t5v0__fill_1
XFILLER_33_261 VDD VDD VSS VSS gf180mcu_fd_sc_mcu7t5v0__fill_1
Xu_core.delay_paths.u_trc0.gen_inv_stage\[50\].inv u_core.delay_paths.u_trc0.gen_inv_stage\[50\].inv/I
+ u_core.delay_paths.u_trc0.gen_inv_stage\[51\].inv/I VDD VDD VSS VSS gf180mcu_fd_sc_mcu7t5v0__inv_1
XFILLER_0_305 VDD VDD VSS VSS gf180mcu_fd_sc_mcu7t5v0__fill_1
Xu_core.delay_paths.u_trc0.gen_inv_stage\[65\].inv u_core.delay_paths.u_trc0.gen_inv_stage\[65\].inv/I
+ u_core.delay_paths.u_trc0.gen_inv_stage\[66\].inv/I VDD VDD VSS VSS gf180mcu_fd_sc_mcu7t5v0__inv_1
XFILLER_31_209 VDD VDD VSS VSS gf180mcu_fd_sc_mcu7t5v0__fill_1
XTAP_TAPCELL_ROW_26_289 VDD VSS gf180mcu_fd_sc_mcu7t5v0__filltie
Xu_core.delay_paths.u_trc0.gen_inv_stage\[18\].inv u_core.delay_paths.u_trc0.gen_inv_stage\[18\].inv/I
+ u_core.delay_paths.u_trc0.gen_inv_stage\[19\].inv/I VDD VDD VSS VSS gf180mcu_fd_sc_mcu7t5v0__inv_1
XFILLER_22_209 VDD VDD VSS VSS gf180mcu_fd_sc_mcu7t5v0__fill_2
XTAP_TAPCELL_ROW_17_234 VDD VSS gf180mcu_fd_sc_mcu7t5v0__filltie
XFILLER_30_242 VDD VDD VSS VSS gf180mcu_fd_sc_mcu7t5v0__fill_2
XFILLER_30_297 VDD VDD VSS VSS gf180mcu_fd_sc_mcu7t5v0__fill_2
XTAP_TAPCELL_ROW_0_124 VDD VSS gf180mcu_fd_sc_mcu7t5v0__filltie
XFILLER_13_209 VDD VDD VSS VSS gf180mcu_fd_sc_mcu7t5v0__fill_1
XFILLER_21_220 VDD VDD VSS VSS gf180mcu_fd_sc_mcu7t5v0__fill_1
XFILLER_0_168 VDD VDD VSS VSS gf180mcu_fd_sc_mcu7t5v0__fill_2
X_700_ _700_/D _700_/RN _700_/CLK _700_/Q VDD VDD VSS VSS gf180mcu_fd_sc_mcu7t5v0__dffrnq_1
XFILLER_28_53 VDD VDD VSS VSS gf180mcu_fd_sc_mcu7t5v0__fill_2
XFILLER_28_64 VDD VDD VSS VSS gf180mcu_fd_sc_mcu7t5v0__fillcap_8
XFILLER_44_312 VDD VDD VSS VSS gf180mcu_fd_sc_mcu7t5v0__fill_2
X_631_ _631_/D _631_/RN _626_/CLK _631_/Q VDD VDD VSS VSS gf180mcu_fd_sc_mcu7t5v0__dffnrnq_1
X_562_ _697_/Q _565_/A2 _562_/B1 _701_/Q _565_/C _563_/A2 VDD VDD VSS VSS gf180mcu_fd_sc_mcu7t5v0__aoi221_1
X_493_ _668_/Q _667_/Q _669_/Q _494_/A1 _494_/B1 VDD VDD VSS VSS gf180mcu_fd_sc_mcu7t5v0__nand4_1
XFILLER_8_235 VDD VDD VSS VSS gf180mcu_fd_sc_mcu7t5v0__fill_2
XTAP_TAPCELL_ROW_14_215 VDD VSS gf180mcu_fd_sc_mcu7t5v0__filltie
XFILLER_35_323 VDD VDD VSS VSS gf180mcu_fd_sc_mcu7t5v0__fill_2
XFILLER_39_139 VDD VDD VSS VSS gf180mcu_fd_sc_mcu7t5v0__fill_1
XFILLER_7_290 VDD VDD VSS VSS gf180mcu_fd_sc_mcu7t5v0__fillcap_4
Xu_core.delay_paths.u_trc2.gen_inv_stage\[9\].inv u_core.delay_paths.u_trc2.gen_inv_stage\[9\].inv/I
+ u_core.delay_paths.u_trc2.gen_inv_stage\[9\].inv/ZN VDD VDD VSS VSS gf180mcu_fd_sc_mcu7t5v0__inv_1
XFILLER_26_312 VDD VDD VSS VSS gf180mcu_fd_sc_mcu7t5v0__fill_2
XFILLER_53_142 VDD VDD VSS VSS gf180mcu_fd_sc_mcu7t5v0__fillcap_64
Xu_core.delay_paths.u_trc3.gen_inv_stage\[41\].inv u_core.delay_paths.u_trc3.gen_inv_stage\[41\].inv/I
+ u_core.delay_paths.u_trc3.gen_inv_stage\[42\].inv/I VDD VDD VSS VSS gf180mcu_fd_sc_mcu7t5v0__inv_1
XFILLER_1_422 VDD VDD VSS VSS gf180mcu_fd_sc_mcu7t5v0__fillcap_8
XFILLER_30_98 VDD VDD VSS VSS gf180mcu_fd_sc_mcu7t5v0__fillcap_4
XFILLER_39_30 VDD VDD VSS VSS gf180mcu_fd_sc_mcu7t5v0__fill_2
XTAP_TAPCELL_ROW_59_487 VDD VSS gf180mcu_fd_sc_mcu7t5v0__filltie
XPHY_EDGE_ROW_34_Left_95 VDD VSS gf180mcu_fd_sc_mcu7t5v0__endcap
XFILLER_17_345 VDD VDD VSS VSS gf180mcu_fd_sc_mcu7t5v0__fill_1
XFILLER_44_131 VDD VDD VSS VSS gf180mcu_fd_sc_mcu7t5v0__fillcap_16
XFILLER_44_164 VDD VDD VSS VSS gf180mcu_fd_sc_mcu7t5v0__fill_1
XFILLER_44_186 VDD VDD VSS VSS gf180mcu_fd_sc_mcu7t5v0__fill_2
X_614_ _614_/D _614_/RN _615_/CLK _615_/D VDD VDD VSS VSS gf180mcu_fd_sc_mcu7t5v0__dffrnq_1
X_545_ _659_/Q _547_/A1 _546_/B VDD VDD VSS VSS gf180mcu_fd_sc_mcu7t5v0__nand2_1
X_476_ _666_/Q _474_/Z _477_/A2 VDD VDD VSS VSS gf180mcu_fd_sc_mcu7t5v0__xnor2_1
XFILLER_35_142 VDD VDD VSS VSS gf180mcu_fd_sc_mcu7t5v0__fillcap_16
XFILLER_50_101 VDD VDD VSS VSS gf180mcu_fd_sc_mcu7t5v0__fillcap_4
XFILLER_46_429 VDD VDD VSS VSS gf180mcu_fd_sc_mcu7t5v0__fill_1
XFILLER_26_197 VDD VDD VSS VSS gf180mcu_fd_sc_mcu7t5v0__fill_2
X_330_ _653_/Q _546_/A2 VDD VDD VSS VSS gf180mcu_fd_sc_mcu7t5v0__clkinv_1
XTAP_TAPCELL_ROW_56_468 VDD VSS gf180mcu_fd_sc_mcu7t5v0__filltie
XFILLER_22_370 VDD VDD VSS VSS gf180mcu_fd_sc_mcu7t5v0__fillcap_8
XFILLER_49_212 VDD VDD VSS VSS gf180mcu_fd_sc_mcu7t5v0__fillcap_64
XTAP_TAPCELL_ROW_47_413 VDD VSS gf180mcu_fd_sc_mcu7t5v0__filltie
XFILLER_20_329 VDD VDD VSS VSS gf180mcu_fd_sc_mcu7t5v0__fill_2
XFILLER_60_410 VDD VDD VSS VSS gf180mcu_fd_sc_mcu7t5v0__fillcap_16
X_528_ _644_/Q _638_/Q _528_/S _638_/D VDD VDD VSS VSS gf180mcu_fd_sc_mcu7t5v0__mux2_2
X_459_ _607_/Q _609_/Q _705_/D VDD VDD VSS VSS gf180mcu_fd_sc_mcu7t5v0__or2_1
XTAP_TAPCELL_ROW_30_313 VDD VSS gf180mcu_fd_sc_mcu7t5v0__filltie
XFILLER_56_2 VDD VDD VSS VSS gf180mcu_fd_sc_mcu7t5v0__fillcap_32
Xu_core.delay_paths.u_trc2.gen_inv_stage\[80\].inv u_core.delay_paths.u_trc2.gen_inv_stage\[80\].inv/I
+ u_core.delay_paths.u_trc2.gen_inv_stage\[81\].inv/I VDD VDD VSS VSS gf180mcu_fd_sc_mcu7t5v0__inv_1
XFILLER_28_429 VDD VDD VSS VSS gf180mcu_fd_sc_mcu7t5v0__fill_1
Xu_core.delay_paths.u_trc2.gen_inv_stage\[95\].inv u_core.delay_paths.u_trc2.gen_inv_stage\[95\].inv/I
+ _723_/I VDD VDD VSS VSS gf180mcu_fd_sc_mcu7t5v0__inv_1
Xclkbuf_0_iCLK iCLK clkbuf_0_iCLK/Z VDD VDD VSS VSS gf180mcu_fd_sc_mcu7t5v0__clkbuf_16
XTAP_TAPCELL_ROW_53_449 VDD VSS gf180mcu_fd_sc_mcu7t5v0__filltie
Xu_core.delay_paths.u_trc2.gen_inv_stage\[33\].inv u_core.delay_paths.u_trc2.gen_inv_stage\[33\].inv/I
+ u_core.delay_paths.u_trc2.gen_inv_stage\[34\].inv/I VDD VDD VSS VSS gf180mcu_fd_sc_mcu7t5v0__inv_1
Xu_core.delay_paths.u_trc2.gen_inv_stage\[48\].inv u_core.delay_paths.u_trc2.gen_inv_stage\[48\].inv/I
+ u_core.delay_paths.u_trc2.gen_inv_stage\[49\].inv/I VDD VDD VSS VSS gf180mcu_fd_sc_mcu7t5v0__inv_1
XFILLER_36_53 VDD VDD VSS VSS gf180mcu_fd_sc_mcu7t5v0__fillcap_4
XFILLER_14_123 VDD VDD VSS VSS gf180mcu_fd_sc_mcu7t5v0__fillcap_4
X_313_ _660_/Q _579_/A1 VDD VDD VSS VSS gf180mcu_fd_sc_mcu7t5v0__clkinv_1
XFILLER_6_300 VDD VDD VSS VSS gf180mcu_fd_sc_mcu7t5v0__fill_2
XFILLER_6_355 VDD VDD VSS VSS gf180mcu_fd_sc_mcu7t5v0__fill_1
XFILLER_6_399 VDD VDD VSS VSS gf180mcu_fd_sc_mcu7t5v0__fill_1
XTAP_TAPCELL_ROW_9_182 VDD VSS gf180mcu_fd_sc_mcu7t5v0__filltie
XFILLER_60_240 VDD VDD VSS VSS gf180mcu_fd_sc_mcu7t5v0__fillcap_4
Xu_core.delay_paths.u_trc1.gen_inv_stage\[120\].inv u_core.delay_paths.u_trc1.gen_inv_stage\[120\].inv/I
+ u_core.delay_paths.u_trc1.gen_inv_stage\[121\].inv/I VDD VDD VSS VSS gf180mcu_fd_sc_mcu7t5v0__inv_1
Xu_core.delay_paths.u_trc1.gen_inv_stage\[135\].inv u_core.delay_paths.u_trc1.gen_inv_stage\[135\].inv/I
+ u_core.delay_paths.u_trc1.gen_inv_stage\[136\].inv/I VDD VDD VSS VSS gf180mcu_fd_sc_mcu7t5v0__inv_1
XPHY_EDGE_ROW_21_Left_82 VDD VSS gf180mcu_fd_sc_mcu7t5v0__endcap
XFILLER_9_182 VDD VDD VSS VSS gf180mcu_fd_sc_mcu7t5v0__fillcap_8
XFILLER_19_204 VDD VDD VSS VSS gf180mcu_fd_sc_mcu7t5v0__fillcap_4
XFILLER_15_410 VDD VDD VSS VSS gf180mcu_fd_sc_mcu7t5v0__fill_2
XFILLER_27_270 VDD VDD VSS VSS gf180mcu_fd_sc_mcu7t5v0__fillcap_4
XFILLER_19_2 VDD VDD VSS VSS gf180mcu_fd_sc_mcu7t5v0__fillcap_64
XFILLER_2_391 VDD VDD VSS VSS gf180mcu_fd_sc_mcu7t5v0__fillcap_32
Xu_core.delay_paths.u_trc1.gen_inv_stage\[72\].inv u_core.delay_paths.u_trc1.gen_inv_stage\[72\].inv/I
+ u_core.delay_paths.u_trc1.gen_inv_stage\[73\].inv/I VDD VDD VSS VSS gf180mcu_fd_sc_mcu7t5v0__inv_1
XFILLER_25_218 VDD VDD VSS VSS gf180mcu_fd_sc_mcu7t5v0__fill_1
Xu_core.delay_paths.u_trc1.gen_inv_stage\[87\].inv u_core.delay_paths.u_trc1.gen_inv_stage\[87\].inv/I
+ u_core.delay_paths.u_trc1.gen_inv_stage\[88\].inv/I VDD VDD VSS VSS gf180mcu_fd_sc_mcu7t5v0__inv_1
Xu_core.delay_paths.u_trc1.gen_inv_stage\[10\].inv u_core.delay_paths.u_trc1.gen_inv_stage\[9\].inv/ZN
+ u_core.delay_paths.u_trc1.gen_inv_stage\[11\].inv/I VDD VDD VSS VSS gf180mcu_fd_sc_mcu7t5v0__inv_1
XFILLER_0_339 VDD VDD VSS VSS gf180mcu_fd_sc_mcu7t5v0__fill_1
Xu_core.delay_paths.u_trc1.gen_inv_stage\[25\].inv u_core.delay_paths.u_trc1.gen_inv_stage\[25\].inv/I
+ u_core.delay_paths.u_trc1.gen_inv_stage\[26\].inv/I VDD VDD VSS VSS gf180mcu_fd_sc_mcu7t5v0__inv_1
XFILLER_17_66 VDD VDD VSS VSS gf180mcu_fd_sc_mcu7t5v0__fillcap_4
XFILLER_56_387 VDD VDD VSS VSS gf180mcu_fd_sc_mcu7t5v0__fillcap_32
XFILLER_15_273 VDD VDD VSS VSS gf180mcu_fd_sc_mcu7t5v0__fillcap_4
XTAP_TAPCELL_ROW_17_235 VDD VSS gf180mcu_fd_sc_mcu7t5v0__filltie
XFILLER_38_321 VDD VDD VSS VSS gf180mcu_fd_sc_mcu7t5v0__fill_2
XFILLER_38_387 VDD VDD VSS VSS gf180mcu_fd_sc_mcu7t5v0__fillcap_32
XFILLER_53_346 VDD VDD VSS VSS gf180mcu_fd_sc_mcu7t5v0__fillcap_4
XTAP_TAPCELL_ROW_0_125 VDD VSS gf180mcu_fd_sc_mcu7t5v0__filltie
XFILLER_21_265 VDD VDD VSS VSS gf180mcu_fd_sc_mcu7t5v0__fillcap_8
Xu_core.delay_paths.u_trc0.gen_inv_stage\[160\].inv u_core.delay_paths.u_trc0.gen_inv_stage\[160\].inv/I
+ u_core.delay_paths.u_trc0.gen_inv_stage\[161\].inv/I VDD VDD VSS VSS gf180mcu_fd_sc_mcu7t5v0__inv_1
XPHY_EDGE_ROW_3_Right_3 VDD VSS gf180mcu_fd_sc_mcu7t5v0__endcap
Xu_core.delay_paths.u_trc0.gen_inv_stage\[175\].inv u_core.delay_paths.u_trc0.gen_inv_stage\[175\].inv/I
+ u_core.delay_paths.u_trc0.gen_inv_stage\[176\].inv/I VDD VDD VSS VSS gf180mcu_fd_sc_mcu7t5v0__inv_1
XFILLER_29_332 VDD VDD VSS VSS gf180mcu_fd_sc_mcu7t5v0__fillcap_4
XFILLER_48_107 VDD VDD VSS VSS gf180mcu_fd_sc_mcu7t5v0__fill_2
X_630_ _630_/D _630_/RN _626_/CLK _630_/Q VDD VDD VSS VSS gf180mcu_fd_sc_mcu7t5v0__dffnrnq_1
XFILLER_12_210 VDD VDD VSS VSS gf180mcu_fd_sc_mcu7t5v0__fill_1
XFILLER_28_87 VDD VDD VSS VSS gf180mcu_fd_sc_mcu7t5v0__fillcap_16
XFILLER_29_376 VDD VDD VSS VSS gf180mcu_fd_sc_mcu7t5v0__fill_2
Xu_core.delay_paths.u_trc0.gen_inv_stage\[113\].inv u_core.delay_paths.u_trc0.gen_inv_stage\[113\].inv/I
+ u_core.delay_paths.u_trc0.gen_inv_stage\[114\].inv/I VDD VDD VSS VSS gf180mcu_fd_sc_mcu7t5v0__inv_2
X_561_ _657_/Q _560_/Z _561_/B _565_/C VDD VDD VSS VSS gf180mcu_fd_sc_mcu7t5v0__oai21_1
X_492_ _492_/A1 _492_/A2 _494_/A2 VDD VDD VSS VSS gf180mcu_fd_sc_mcu7t5v0__nand2_1
XTAP_TAPCELL_ROW_14_216 VDD VSS gf180mcu_fd_sc_mcu7t5v0__filltie
XFILLER_8_214 VDD VDD VSS VSS gf180mcu_fd_sc_mcu7t5v0__fillcap_4
Xu_core.delay_paths.u_trc0.gen_inv_stage\[128\].inv u_core.delay_paths.u_trc0.gen_inv_stage\[128\].inv/I
+ u_core.delay_paths.u_trc0.gen_inv_stage\[129\].inv/I VDD VDD VSS VSS gf180mcu_fd_sc_mcu7t5v0__inv_1
XTAP_TAPCELL_ROW_22_260 VDD VSS gf180mcu_fd_sc_mcu7t5v0__filltie
XFILLER_47_173 VDD VDD VSS VSS gf180mcu_fd_sc_mcu7t5v0__fill_2
Xu_core.delay_paths.u_trc0.gen_inv_stage\[64\].inv u_core.delay_paths.u_trc0.gen_inv_stage\[64\].inv/I
+ u_core.delay_paths.u_trc0.gen_inv_stage\[65\].inv/I VDD VDD VSS VSS gf180mcu_fd_sc_mcu7t5v0__inv_1
Xu_core.delay_paths.u_trc0.gen_inv_stage\[79\].inv u_core.delay_paths.u_trc0.gen_inv_stage\[79\].inv/I
+ u_core.delay_paths.u_trc0.gen_inv_stage\[80\].inv/I VDD VDD VSS VSS gf180mcu_fd_sc_mcu7t5v0__inv_2
XFILLER_58_427 VDD VDD VSS VSS gf180mcu_fd_sc_mcu7t5v0__fill_2
XFILLER_38_151 VDD VDD VSS VSS gf180mcu_fd_sc_mcu7t5v0__fill_1
XFILLER_41_349 VDD VDD VSS VSS gf180mcu_fd_sc_mcu7t5v0__fill_1
Xu_core.delay_paths.u_trc0.gen_inv_stage\[17\].inv u_core.delay_paths.u_trc0.gen_inv_stage\[17\].inv/I
+ u_core.delay_paths.u_trc0.gen_inv_stage\[18\].inv/I VDD VDD VSS VSS gf180mcu_fd_sc_mcu7t5v0__inv_1
XFILLER_14_34 VDD VDD VSS VSS gf180mcu_fd_sc_mcu7t5v0__fill_1
XFILLER_49_416 VDD VDD VSS VSS gf180mcu_fd_sc_mcu7t5v0__fillcap_4
X_613_ _613_/D _613_/RN _615_/CLK _614_/D VDD VDD VSS VSS gf180mcu_fd_sc_mcu7t5v0__dffrnq_1
X_544_ _544_/A1 _696_/D _544_/B _652_/D VDD VDD VSS VSS gf180mcu_fd_sc_mcu7t5v0__oai21_1
X_475_ _466_/Z _475_/A2 _474_/Z _665_/D VDD VDD VSS VSS gf180mcu_fd_sc_mcu7t5v0__nor3_1
XFILLER_31_360 VDD VDD VSS VSS gf180mcu_fd_sc_mcu7t5v0__fill_1
XFILLER_46_419 VDD VDD VSS VSS gf180mcu_fd_sc_mcu7t5v0__fillcap_8
XFILLER_25_66 VDD VDD VSS VSS gf180mcu_fd_sc_mcu7t5v0__fillcap_4
XTAP_TAPCELL_ROW_56_469 VDD VSS gf180mcu_fd_sc_mcu7t5v0__filltie
XFILLER_22_382 VDD VDD VSS VSS gf180mcu_fd_sc_mcu7t5v0__fill_2
XFILLER_22_393 VDD VDD VSS VSS gf180mcu_fd_sc_mcu7t5v0__fill_1
XFILLER_41_76 VDD VDD VSS VSS gf180mcu_fd_sc_mcu7t5v0__fill_2
Xu_core.delay_paths.u_trc0.gen_inv_stage\[9\].inv u_core.delay_paths.u_trc0.gen_inv_stage\[9\].inv/I
+ u_core.delay_paths.u_trc0.gen_inv_stage\[9\].inv/ZN VDD VDD VSS VSS gf180mcu_fd_sc_mcu7t5v0__inv_2
XFILLER_2_37 VDD VDD VSS VSS gf180mcu_fd_sc_mcu7t5v0__fill_2
X_527_ _527_/A1 _527_/A2 _527_/B _637_/D VDD VDD VSS VSS gf180mcu_fd_sc_mcu7t5v0__aoi21_1
XTAP_TAPCELL_ROW_47_414 VDD VSS gf180mcu_fd_sc_mcu7t5v0__filltie
XFILLER_32_157 VDD VDD VSS VSS gf180mcu_fd_sc_mcu7t5v0__fill_1
Xu_core.delay_paths.u_trc2.gen_inv_stage\[8\].inv u_core.delay_paths.u_trc2.gen_inv_stage\[8\].inv/I
+ u_core.delay_paths.u_trc2.gen_inv_stage\[9\].inv/I VDD VDD VSS VSS gf180mcu_fd_sc_mcu7t5v0__inv_1
X_458_ _649_/Q _651_/Q _646_/Q _688_/D VDD VDD VSS VSS gf180mcu_fd_sc_mcu7t5v0__mux2_2
X_389_ _507_/A1 _389_/A2 _389_/B _395_/A2 VDD VDD VSS VSS gf180mcu_fd_sc_mcu7t5v0__oai21_1
XFILLER_9_364 VDD VDD VSS VSS gf180mcu_fd_sc_mcu7t5v0__fill_1
XFILLER_49_2 VDD VDD VSS VSS gf180mcu_fd_sc_mcu7t5v0__fillcap_64
Xu_core.delay_paths.u_trc3.gen_inv_stage\[40\].inv u_core.delay_paths.u_trc3.gen_inv_stage\[40\].inv/I
+ u_core.delay_paths.u_trc3.gen_inv_stage\[41\].inv/I VDD VDD VSS VSS gf180mcu_fd_sc_mcu7t5v0__inv_1
Xtrc_top_50 oSPI_MISO_IE VDD VDD VSS VSS gf180mcu_fd_sc_mcu7t5v0__tiel
XFILLER_28_419 VDD VDD VSS VSS gf180mcu_fd_sc_mcu7t5v0__fillcap_8
XFILLER_23_113 VDD VDD VSS VSS gf180mcu_fd_sc_mcu7t5v0__fill_2
XFILLER_23_146 VDD VDD VSS VSS gf180mcu_fd_sc_mcu7t5v0__fill_1
XFILLER_51_422 VDD VDD VSS VSS gf180mcu_fd_sc_mcu7t5v0__fillcap_8
XFILLER_36_76 VDD VDD VSS VSS gf180mcu_fd_sc_mcu7t5v0__fillcap_4
XFILLER_46_205 VDD VDD VSS VSS gf180mcu_fd_sc_mcu7t5v0__fill_2
XFILLER_14_146 VDD VDD VSS VSS gf180mcu_fd_sc_mcu7t5v0__fill_1
XFILLER_14_179 VDD VDD VSS VSS gf180mcu_fd_sc_mcu7t5v0__fill_1
X_312_ _312_/I _584_/A1 VDD VDD VSS VSS gf180mcu_fd_sc_mcu7t5v0__clkinv_1
XFILLER_10_374 VDD VDD VSS VSS gf180mcu_fd_sc_mcu7t5v0__fill_1
XFILLER_6_345 VDD VDD VSS VSS gf180mcu_fd_sc_mcu7t5v0__fill_1
XFILLER_6_378 VDD VDD VSS VSS gf180mcu_fd_sc_mcu7t5v0__fill_1
XFILLER_37_216 VDD VDD VSS VSS gf180mcu_fd_sc_mcu7t5v0__fill_2
XTAP_TAPCELL_ROW_9_183 VDD VSS gf180mcu_fd_sc_mcu7t5v0__filltie
XFILLER_33_411 VDD VDD VSS VSS gf180mcu_fd_sc_mcu7t5v0__fillcap_8
XFILLER_33_422 VDD VDD VSS VSS gf180mcu_fd_sc_mcu7t5v0__fill_2
XFILLER_60_274 VDD VDD VSS VSS gf180mcu_fd_sc_mcu7t5v0__fillcap_32
XFILLER_9_161 VDD VDD VSS VSS gf180mcu_fd_sc_mcu7t5v0__fill_1
XFILLER_11_116 VDD VDD VSS VSS gf180mcu_fd_sc_mcu7t5v0__fillcap_16
XFILLER_11_149 VDD VDD VSS VSS gf180mcu_fd_sc_mcu7t5v0__fillcap_16
XFILLER_22_34 VDD VDD VSS VSS gf180mcu_fd_sc_mcu7t5v0__fill_1
XFILLER_3_348 VDD VDD VSS VSS gf180mcu_fd_sc_mcu7t5v0__fill_2
XFILLER_59_352 VDD VDD VSS VSS gf180mcu_fd_sc_mcu7t5v0__fillcap_64
XTAP_TAPCELL_ROW_6_164 VDD VSS gf180mcu_fd_sc_mcu7t5v0__filltie
XFILLER_47_97 VDD VDD VSS VSS gf180mcu_fd_sc_mcu7t5v0__fillcap_16
Xu_core.delay_paths.u_trc2.gen_inv_stage\[94\].inv u_core.delay_paths.u_trc2.gen_inv_stage\[94\].inv/I
+ u_core.delay_paths.u_trc2.gen_inv_stage\[95\].inv/I VDD VDD VSS VSS gf180mcu_fd_sc_mcu7t5v0__inv_1
XFILLER_6_197 VDD VDD VSS VSS gf180mcu_fd_sc_mcu7t5v0__fill_2
Xu_core.delay_paths.u_trc2.gen_inv_stage\[32\].inv u_core.delay_paths.u_trc2.gen_inv_stage\[32\].inv/I
+ u_core.delay_paths.u_trc2.gen_inv_stage\[33\].inv/I VDD VDD VSS VSS gf180mcu_fd_sc_mcu7t5v0__inv_1
Xu_core.delay_paths.u_trc2.gen_inv_stage\[47\].inv u_core.delay_paths.u_trc2.gen_inv_stage\[47\].inv/I
+ u_core.delay_paths.u_trc2.gen_inv_stage\[48\].inv/I VDD VDD VSS VSS gf180mcu_fd_sc_mcu7t5v0__inv_1
XFILLER_56_311 VDD VDD VSS VSS gf180mcu_fd_sc_mcu7t5v0__fillcap_4
XFILLER_16_208 VDD VDD VSS VSS gf180mcu_fd_sc_mcu7t5v0__fillcap_4
XPHY_EDGE_ROW_49_Left_110 VDD VSS gf180mcu_fd_sc_mcu7t5v0__endcap
XFILLER_8_429 VDD VDD VSS VSS gf180mcu_fd_sc_mcu7t5v0__fill_1
Xu_core.delay_paths.u_trc1.gen_inv_stage\[134\].inv u_core.delay_paths.u_trc1.gen_inv_stage\[134\].inv/I
+ u_core.delay_paths.u_trc1.gen_inv_stage\[135\].inv/I VDD VDD VSS VSS gf180mcu_fd_sc_mcu7t5v0__inv_1
XFILLER_30_244 VDD VDD VSS VSS gf180mcu_fd_sc_mcu7t5v0__fill_1
XTAP_TAPCELL_ROW_25_280 VDD VSS gf180mcu_fd_sc_mcu7t5v0__filltie
XFILLER_31_2 VDD VDD VSS VSS gf180mcu_fd_sc_mcu7t5v0__fillcap_64
XFILLER_0_70 VDD VDD VSS VSS gf180mcu_fd_sc_mcu7t5v0__fill_1
XTAP_TAPCELL_ROW_0_126 VDD VSS gf180mcu_fd_sc_mcu7t5v0__filltie
XFILLER_21_277 VDD VDD VSS VSS gf180mcu_fd_sc_mcu7t5v0__fill_2
XFILLER_28_55 VDD VDD VSS VSS gf180mcu_fd_sc_mcu7t5v0__fill_1
XFILLER_44_314 VDD VDD VSS VSS gf180mcu_fd_sc_mcu7t5v0__fill_1
X_560_ _656_/Q _582_/A1 _560_/Z VDD VDD VSS VSS gf180mcu_fd_sc_mcu7t5v0__or2_1
XFILLER_44_65 VDD VDD VSS VSS gf180mcu_fd_sc_mcu7t5v0__fill_2
X_491_ _669_/Q _491_/A2 _491_/B _669_/D VDD VDD VSS VSS gf180mcu_fd_sc_mcu7t5v0__oai21_1
XTAP_TAPCELL_ROW_14_217 VDD VSS gf180mcu_fd_sc_mcu7t5v0__filltie
XFILLER_12_299 VDD VDD VSS VSS gf180mcu_fd_sc_mcu7t5v0__fill_1
XFILLER_8_237 VDD VDD VSS VSS gf180mcu_fd_sc_mcu7t5v0__fill_1
Xu_core.delay_paths.u_trc1.gen_inv_stage\[71\].inv u_core.delay_paths.u_trc1.gen_inv_stage\[71\].inv/I
+ u_core.delay_paths.u_trc1.gen_inv_stage\[72\].inv/I VDD VDD VSS VSS gf180mcu_fd_sc_mcu7t5v0__inv_1
XTAP_TAPCELL_ROW_22_261 VDD VSS gf180mcu_fd_sc_mcu7t5v0__filltie
Xu_core.delay_paths.u_trc1.gen_inv_stage\[86\].inv u_core.delay_paths.u_trc1.gen_inv_stage\[86\].inv/I
+ u_core.delay_paths.u_trc1.gen_inv_stage\[87\].inv/I VDD VDD VSS VSS gf180mcu_fd_sc_mcu7t5v0__inv_1
XFILLER_35_325 VDD VDD VSS VSS gf180mcu_fd_sc_mcu7t5v0__fill_1
X_689_ _689_/D _704_/RN _692_/CLK _689_/Q VDD VDD VSS VSS gf180mcu_fd_sc_mcu7t5v0__dffrnq_1
XPHY_EDGE_ROW_13_Right_13 VDD VSS gf180mcu_fd_sc_mcu7t5v0__endcap
XFILLER_50_317 VDD VDD VSS VSS gf180mcu_fd_sc_mcu7t5v0__fillcap_64
Xu_core.delay_paths.u_trc1.gen_inv_stage\[24\].inv u_core.delay_paths.u_trc1.gen_inv_stage\[24\].inv/I
+ u_core.delay_paths.u_trc1.gen_inv_stage\[25\].inv/I VDD VDD VSS VSS gf180mcu_fd_sc_mcu7t5v0__inv_1
XPHY_EDGE_ROW_22_Right_22 VDD VSS gf180mcu_fd_sc_mcu7t5v0__endcap
Xu_core.delay_paths.u_trc1.gen_inv_stage\[39\].inv u_core.delay_paths.u_trc1.gen_inv_stage\[39\].inv/I
+ u_core.delay_paths.u_trc1.gen_inv_stage\[40\].inv/I VDD VDD VSS VSS gf180mcu_fd_sc_mcu7t5v0__inv_1
XPHY_EDGE_ROW_31_Right_31 VDD VSS gf180mcu_fd_sc_mcu7t5v0__endcap
XFILLER_26_314 VDD VDD VSS VSS gf180mcu_fd_sc_mcu7t5v0__fill_1
XFILLER_26_358 VDD VDD VSS VSS gf180mcu_fd_sc_mcu7t5v0__fillcap_16
XFILLER_34_380 VDD VDD VSS VSS gf180mcu_fd_sc_mcu7t5v0__fillcap_4
XFILLER_30_34 VDD VDD VSS VSS gf180mcu_fd_sc_mcu7t5v0__fill_1
XPHY_EDGE_ROW_40_Right_40 VDD VSS gf180mcu_fd_sc_mcu7t5v0__endcap
XFILLER_39_32 VDD VDD VSS VSS gf180mcu_fd_sc_mcu7t5v0__fill_1
XFILLER_29_174 VDD VDD VSS VSS gf180mcu_fd_sc_mcu7t5v0__fill_2
X_612_ _612_/D _612_/RN _615_/CLK _613_/D VDD VDD VSS VSS gf180mcu_fd_sc_mcu7t5v0__dffrnq_1
X_543_ _658_/Q _547_/A1 _544_/B VDD VDD VSS VSS gf180mcu_fd_sc_mcu7t5v0__nand2_1
XFILLER_32_317 VDD VDD VSS VSS gf180mcu_fd_sc_mcu7t5v0__fill_1
X_474_ _700_/Q _665_/Q _411_/C _474_/Z VDD VDD VSS VSS gf180mcu_fd_sc_mcu7t5v0__and3_1
XFILLER_4_251 VDD VDD VSS VSS gf180mcu_fd_sc_mcu7t5v0__fillcap_16
Xu_core.delay_paths.u_trc0.gen_inv_stage\[174\].inv u_core.delay_paths.u_trc0.gen_inv_stage\[174\].inv/I
+ u_core.delay_paths.u_trc0.gen_inv_stage\[175\].inv/I VDD VDD VSS VSS gf180mcu_fd_sc_mcu7t5v0__inv_1
Xu_core.delay_paths.u_trc0.gen_inv_stage\[189\].inv u_core.delay_paths.u_trc0.gen_inv_stage\[189\].inv/I
+ u_core.delay_paths.u_trc0.gen_inv_stage\[190\].inv/I VDD VDD VSS VSS gf180mcu_fd_sc_mcu7t5v0__inv_1
Xu_core.delay_paths.u_trc0.gen_inv_stage\[112\].inv u_core.delay_paths.u_trc0.gen_inv_stage\[112\].inv/I
+ u_core.delay_paths.u_trc0.gen_inv_stage\[113\].inv/I VDD VDD VSS VSS gf180mcu_fd_sc_mcu7t5v0__inv_2
XFILLER_58_247 VDD VDD VSS VSS gf180mcu_fd_sc_mcu7t5v0__fillcap_64
Xu_core.delay_paths.u_trc0.gen_inv_stage\[127\].inv u_core.delay_paths.u_trc0.gen_inv_stage\[127\].inv/I
+ u_core.delay_paths.u_trc0.gen_inv_stage\[128\].inv/I VDD VDD VSS VSS gf180mcu_fd_sc_mcu7t5v0__inv_1
XFILLER_26_177 VDD VDD VSS VSS gf180mcu_fd_sc_mcu7t5v0__fillcap_4
XFILLER_41_158 VDD VDD VSS VSS gf180mcu_fd_sc_mcu7t5v0__fillcap_8
XFILLER_41_66 VDD VDD VSS VSS gf180mcu_fd_sc_mcu7t5v0__fillcap_4
XFILLER_9_2 VDD VDD VSS VSS gf180mcu_fd_sc_mcu7t5v0__fillcap_64
Xu_core.delay_paths.u_trc0.gen_inv_stage\[63\].inv u_core.delay_paths.u_trc0.gen_inv_stage\[63\].inv/I
+ u_core.delay_paths.u_trc0.gen_inv_stage\[64\].inv/I VDD VDD VSS VSS gf180mcu_fd_sc_mcu7t5v0__inv_1
XFILLER_32_103 VDD VDD VSS VSS gf180mcu_fd_sc_mcu7t5v0__fill_2
Xu_core.delay_paths.u_trc0.gen_inv_stage\[78\].inv u_core.delay_paths.u_trc0.gen_inv_stage\[78\].inv/I
+ u_core.delay_paths.u_trc0.gen_inv_stage\[79\].inv/I VDD VDD VSS VSS gf180mcu_fd_sc_mcu7t5v0__inv_2
X_526_ _643_/Q _527_/A2 _527_/B VDD VDD VSS VSS gf180mcu_fd_sc_mcu7t5v0__nor2_1
XTAP_TAPCELL_ROW_47_415 VDD VSS gf180mcu_fd_sc_mcu7t5v0__filltie
XFILLER_20_309 VDD VDD VSS VSS gf180mcu_fd_sc_mcu7t5v0__fillcap_4
Xu_core.delay_paths.u_trc0.gen_inv_stage\[16\].inv u_core.delay_paths.u_trc0.gen_inv_stage\[16\].inv/I
+ u_core.delay_paths.u_trc0.gen_inv_stage\[17\].inv/I VDD VDD VSS VSS gf180mcu_fd_sc_mcu7t5v0__inv_1
X_457_ _648_/Q _650_/Q _646_/Q _687_/D VDD VDD VSS VSS gf180mcu_fd_sc_mcu7t5v0__mux2_2
X_388_ _512_/A1 _371_/Z _388_/B _415_/A1 VDD VDD VSS VSS gf180mcu_fd_sc_mcu7t5v0__oai21_1
Xtrc_top_51 oSPI_MISO_PD VDD VDD VSS VSS gf180mcu_fd_sc_mcu7t5v0__tiel
XFILLER_55_206 VDD VDD VSS VSS gf180mcu_fd_sc_mcu7t5v0__fillcap_4
XFILLER_10_331 VDD VDD VSS VSS gf180mcu_fd_sc_mcu7t5v0__fillcap_4
XFILLER_14_169 VDD VDD VSS VSS gf180mcu_fd_sc_mcu7t5v0__fill_2
X_311_ _700_/Q _414_/C VDD VDD VSS VSS gf180mcu_fd_sc_mcu7t5v0__clkinv_1
XTAP_TAPCELL_ROW_52_440 VDD VSS gf180mcu_fd_sc_mcu7t5v0__filltie
XTAP_TAPCELL_ROW_9_184 VDD VSS gf180mcu_fd_sc_mcu7t5v0__filltie
XFILLER_60_253 VDD VDD VSS VSS gf180mcu_fd_sc_mcu7t5v0__fillcap_16
X_509_ _682_/Q _678_/Q _509_/S _682_/D VDD VDD VSS VSS gf180mcu_fd_sc_mcu7t5v0__mux2_2
XFILLER_5_390 VDD VDD VSS VSS gf180mcu_fd_sc_mcu7t5v0__fillcap_16
Xu_core.delay_paths.u_trc0.gen_inv_stage\[8\].inv u_core.delay_paths.u_trc0.gen_inv_stage\[8\].inv/I
+ u_core.delay_paths.u_trc0.gen_inv_stage\[9\].inv/I VDD VDD VSS VSS gf180mcu_fd_sc_mcu7t5v0__inv_2
Xu_core.delay_paths.u_trc2.gen_inv_stage\[7\].inv u_core.delay_paths.u_trc2.gen_inv_stage\[7\].inv/I
+ u_core.delay_paths.u_trc2.gen_inv_stage\[8\].inv/I VDD VDD VSS VSS gf180mcu_fd_sc_mcu7t5v0__inv_1
XTAP_TAPCELL_ROW_6_165 VDD VSS gf180mcu_fd_sc_mcu7t5v0__filltie
XFILLER_42_231 VDD VDD VSS VSS gf180mcu_fd_sc_mcu7t5v0__fillcap_4
XFILLER_42_264 VDD VDD VSS VSS gf180mcu_fd_sc_mcu7t5v0__fillcap_4
XFILLER_42_286 VDD VDD VSS VSS gf180mcu_fd_sc_mcu7t5v0__fillcap_4
XFILLER_8_37 VDD VDD VSS VSS gf180mcu_fd_sc_mcu7t5v0__fillcap_64
XFILLER_21_426 VDD VDD VSS VSS gf180mcu_fd_sc_mcu7t5v0__fillcap_4
XFILLER_0_308 VDD VDD VSS VSS gf180mcu_fd_sc_mcu7t5v0__fill_2
XTAP_TAPCELL_ROW_3_146 VDD VSS gf180mcu_fd_sc_mcu7t5v0__filltie
XFILLER_24_297 VDD VDD VSS VSS gf180mcu_fd_sc_mcu7t5v0__fill_2
XFILLER_3_113 VDD VDD VSS VSS gf180mcu_fd_sc_mcu7t5v0__fillcap_16
XTAP_TAPCELL_ROW_25_281 VDD VSS gf180mcu_fd_sc_mcu7t5v0__filltie
XFILLER_24_2 VDD VDD VSS VSS gf180mcu_fd_sc_mcu7t5v0__fillcap_32
XFILLER_21_212 VDD VDD VSS VSS gf180mcu_fd_sc_mcu7t5v0__fillcap_8
XTAP_TAPCELL_ROW_0_127 VDD VSS gf180mcu_fd_sc_mcu7t5v0__filltie
XFILLER_0_138 VDD VDD VSS VSS gf180mcu_fd_sc_mcu7t5v0__fill_1
XFILLER_28_34 VDD VDD VSS VSS gf180mcu_fd_sc_mcu7t5v0__fill_1
XFILLER_48_109 VDD VDD VSS VSS gf180mcu_fd_sc_mcu7t5v0__fill_1
Xu_core.delay_paths.u_trc2.gen_inv_stage\[93\].inv u_core.delay_paths.u_trc2.gen_inv_stage\[93\].inv/I
+ u_core.delay_paths.u_trc2.gen_inv_stage\[94\].inv/I VDD VDD VSS VSS gf180mcu_fd_sc_mcu7t5v0__inv_1
XTAP_TAPCELL_ROW_39_362 VDD VSS gf180mcu_fd_sc_mcu7t5v0__filltie
XFILLER_52_381 VDD VDD VSS VSS gf180mcu_fd_sc_mcu7t5v0__fillcap_4
X_490_ _669_/Q _490_/A2 _491_/B VDD VDD VSS VSS gf180mcu_fd_sc_mcu7t5v0__nand2_1
XFILLER_4_411 VDD VDD VSS VSS gf180mcu_fd_sc_mcu7t5v0__fill_2
Xu_core.delay_paths.u_trc2.gen_inv_stage\[31\].inv u_core.delay_paths.u_trc2.gen_inv_stage\[31\].inv/I
+ u_core.delay_paths.u_trc2.gen_inv_stage\[32\].inv/I VDD VDD VSS VSS gf180mcu_fd_sc_mcu7t5v0__inv_1
XTAP_TAPCELL_ROW_22_262 VDD VSS gf180mcu_fd_sc_mcu7t5v0__filltie
Xu_core.delay_paths.u_trc2.gen_inv_stage\[46\].inv u_core.delay_paths.u_trc2.gen_inv_stage\[46\].inv/I
+ u_core.delay_paths.u_trc2.gen_inv_stage\[47\].inv/I VDD VDD VSS VSS gf180mcu_fd_sc_mcu7t5v0__inv_1
XFILLER_35_315 VDD VDD VSS VSS gf180mcu_fd_sc_mcu7t5v0__fillcap_8
XFILLER_47_175 VDD VDD VSS VSS gf180mcu_fd_sc_mcu7t5v0__fill_1
X_688_ _688_/D _704_/RN _688_/CLK _688_/Q VDD VDD VSS VSS gf180mcu_fd_sc_mcu7t5v0__dffrnq_1
XFILLER_7_260 VDD VDD VSS VSS gf180mcu_fd_sc_mcu7t5v0__fillcap_16
XTAP_TAPCELL_ROW_45_398 VDD VSS gf180mcu_fd_sc_mcu7t5v0__filltie
XFILLER_7_282 VDD VDD VSS VSS gf180mcu_fd_sc_mcu7t5v0__fillcap_8
XFILLER_38_197 VDD VDD VSS VSS gf180mcu_fd_sc_mcu7t5v0__fill_2
XFILLER_58_429 VDD VDD VSS VSS gf180mcu_fd_sc_mcu7t5v0__fill_1
XFILLER_14_69 VDD VDD VSS VSS gf180mcu_fd_sc_mcu7t5v0__fillcap_16
XFILLER_30_68 VDD VDD VSS VSS gf180mcu_fd_sc_mcu7t5v0__fillcap_4
Xu_core.delay_paths.u_trc1.gen_inv_stage\[133\].inv u_core.delay_paths.u_trc1.gen_inv_stage\[133\].inv/I
+ u_core.delay_paths.u_trc1.gen_inv_stage\[134\].inv/I VDD VDD VSS VSS gf180mcu_fd_sc_mcu7t5v0__inv_1
XFILLER_39_77 VDD VDD VSS VSS gf180mcu_fd_sc_mcu7t5v0__fill_2
XFILLER_17_315 VDD VDD VSS VSS gf180mcu_fd_sc_mcu7t5v0__fillcap_16
XFILLER_29_142 VDD VDD VSS VSS gf180mcu_fd_sc_mcu7t5v0__fillcap_32
XFILLER_32_329 VDD VDD VSS VSS gf180mcu_fd_sc_mcu7t5v0__fill_1
X_611_ _611_/D _611_/RN _615_/CLK _612_/D VDD VDD VSS VSS gf180mcu_fd_sc_mcu7t5v0__dffrnq_1
X_542_ _651_/Q _657_/Q _696_/D _651_/D VDD VDD VSS VSS gf180mcu_fd_sc_mcu7t5v0__mux2_2
X_473_ _700_/Q _411_/C _665_/Q _475_/A2 VDD VDD VSS VSS gf180mcu_fd_sc_mcu7t5v0__aoi21_1
XFILLER_4_230 VDD VDD VSS VSS gf180mcu_fd_sc_mcu7t5v0__fillcap_4
Xu_core.delay_paths.u_trc1.gen_inv_stage\[70\].inv u_core.delay_paths.u_trc1.gen_inv_stage\[70\].inv/I
+ u_core.delay_paths.u_trc1.gen_inv_stage\[71\].inv/I VDD VDD VSS VSS gf180mcu_fd_sc_mcu7t5v0__inv_1
XFILLER_22_384 VDD VDD VSS VSS gf180mcu_fd_sc_mcu7t5v0__fill_1
XFILLER_41_34 VDD VDD VSS VSS gf180mcu_fd_sc_mcu7t5v0__fillcap_16
Xu_core.delay_paths.u_trc1.gen_inv_stage\[85\].inv u_core.delay_paths.u_trc1.gen_inv_stage\[85\].inv/I
+ u_core.delay_paths.u_trc1.gen_inv_stage\[86\].inv/I VDD VDD VSS VSS gf180mcu_fd_sc_mcu7t5v0__inv_1
XFILLER_41_89 VDD VDD VSS VSS gf180mcu_fd_sc_mcu7t5v0__fill_1
XPHY_EDGE_ROW_38_Left_99 VDD VSS gf180mcu_fd_sc_mcu7t5v0__endcap
XFILLER_17_112 VDD VDD VSS VSS gf180mcu_fd_sc_mcu7t5v0__fillcap_4
XFILLER_1_244 VDD VDD VSS VSS gf180mcu_fd_sc_mcu7t5v0__fillcap_16
XFILLER_2_39 VDD VDD VSS VSS gf180mcu_fd_sc_mcu7t5v0__fill_1
Xu_core.delay_paths.u_trc1.gen_inv_stage\[23\].inv u_core.delay_paths.u_trc1.gen_inv_stage\[23\].inv/I
+ u_core.delay_paths.u_trc1.gen_inv_stage\[24\].inv/I VDD VDD VSS VSS gf180mcu_fd_sc_mcu7t5v0__inv_1
Xu_core.delay_paths.u_trc1.gen_inv_stage\[38\].inv u_core.delay_paths.u_trc1.gen_inv_stage\[38\].inv/I
+ u_core.delay_paths.u_trc1.gen_inv_stage\[39\].inv/I VDD VDD VSS VSS gf180mcu_fd_sc_mcu7t5v0__inv_1
XFILLER_17_178 VDD VDD VSS VSS gf180mcu_fd_sc_mcu7t5v0__fill_2
X_525_ _525_/A1 _527_/A2 _525_/B _636_/D VDD VDD VSS VSS gf180mcu_fd_sc_mcu7t5v0__aoi21_1
X_456_ _456_/A1 _435_/Z _456_/B1 _456_/B2 _633_/D VDD VDD VSS VSS gf180mcu_fd_sc_mcu7t5v0__aoi22_1
XTAP_TAPCELL_ROW_55_460 VDD VSS gf180mcu_fd_sc_mcu7t5v0__filltie
X_387_ _684_/Q _397_/A2 _397_/C _416_/A1 VDD VDD VSS VSS gf180mcu_fd_sc_mcu7t5v0__aoi21_1
Xtrc_top_52 oSPI_MISO_PU VDD VDD VSS VSS gf180mcu_fd_sc_mcu7t5v0__tiel
XFILLER_23_115 VDD VDD VSS VSS gf180mcu_fd_sc_mcu7t5v0__fill_1
XFILLER_36_34 VDD VDD VSS VSS gf180mcu_fd_sc_mcu7t5v0__fill_1
XFILLER_39_292 VDD VDD VSS VSS gf180mcu_fd_sc_mcu7t5v0__fillcap_16
X_310_ _310_/I _405_/A1 VDD VDD VSS VSS gf180mcu_fd_sc_mcu7t5v0__clkinv_1
XTAP_TAPCELL_ROW_52_441 VDD VSS gf180mcu_fd_sc_mcu7t5v0__filltie
XFILLER_10_387 VDD VDD VSS VSS gf180mcu_fd_sc_mcu7t5v0__fillcap_4
XFILLER_6_369 VDD VDD VSS VSS gf180mcu_fd_sc_mcu7t5v0__fill_1
Xu_core.delay_paths.u_trc0.gen_inv_stage\[173\].inv u_core.delay_paths.u_trc0.gen_inv_stage\[173\].inv/I
+ u_core.delay_paths.u_trc0.gen_inv_stage\[174\].inv/I VDD VDD VSS VSS gf180mcu_fd_sc_mcu7t5v0__clkinv_1
XTAP_TAPCELL_ROW_9_185 VDD VSS gf180mcu_fd_sc_mcu7t5v0__filltie
Xu_core.delay_paths.u_trc0.gen_inv_stage\[188\].inv u_core.delay_paths.u_trc0.gen_inv_stage\[188\].inv/I
+ u_core.delay_paths.u_trc0.gen_inv_stage\[189\].inv/I VDD VDD VSS VSS gf180mcu_fd_sc_mcu7t5v0__inv_1
Xu_core.delay_paths.u_trc0.gen_inv_stage\[111\].inv u_core.delay_paths.u_trc0.gen_inv_stage\[111\].inv/I
+ u_core.delay_paths.u_trc0.gen_inv_stage\[112\].inv/I VDD VDD VSS VSS gf180mcu_fd_sc_mcu7t5v0__inv_2
X_508_ _681_/Q _677_/Q _509_/S _681_/D VDD VDD VSS VSS gf180mcu_fd_sc_mcu7t5v0__mux2_2
X_439_ _692_/Q _447_/A2 _535_/A2 _645_/Q _437_/Z _634_/Q _440_/A2 VDD VDD VSS VSS
+ gf180mcu_fd_sc_mcu7t5v0__aoi222_1
XFILLER_54_2 VDD VDD VSS VSS gf180mcu_fd_sc_mcu7t5v0__fillcap_32
Xu_core.delay_paths.u_trc0.gen_inv_stage\[126\].inv u_core.delay_paths.u_trc0.gen_inv_stage\[126\].inv/I
+ u_core.delay_paths.u_trc0.gen_inv_stage\[127\].inv/I VDD VDD VSS VSS gf180mcu_fd_sc_mcu7t5v0__inv_1
Xwire11 wire11/I oSPI_MISO_OUT VDD VDD VSS VSS gf180mcu_fd_sc_mcu7t5v0__clkbuf_3
XFILLER_22_69 VDD VDD VSS VSS gf180mcu_fd_sc_mcu7t5v0__fillcap_16
XFILLER_51_276 VDD VDD VSS VSS gf180mcu_fd_sc_mcu7t5v0__fillcap_4
Xu_core.delay_paths.u_trc0.gen_inv_stage\[62\].inv u_core.delay_paths.u_trc0.gen_inv_stage\[62\].inv/I
+ u_core.delay_paths.u_trc0.gen_inv_stage\[63\].inv/I VDD VDD VSS VSS gf180mcu_fd_sc_mcu7t5v0__inv_1
Xu_core.delay_paths.u_trc0.gen_inv_stage\[77\].inv u_core.delay_paths.u_trc0.gen_inv_stage\[77\].inv/I
+ u_core.delay_paths.u_trc0.gen_inv_stage\[78\].inv/I VDD VDD VSS VSS gf180mcu_fd_sc_mcu7t5v0__inv_2
XFILLER_15_402 VDD VDD VSS VSS gf180mcu_fd_sc_mcu7t5v0__fillcap_8
XFILLER_27_262 VDD VDD VSS VSS gf180mcu_fd_sc_mcu7t5v0__fillcap_8
XFILLER_47_66 VDD VDD VSS VSS gf180mcu_fd_sc_mcu7t5v0__fillcap_4
Xu_core.delay_paths.u_trc0.gen_inv_stage\[15\].inv u_core.delay_paths.u_trc0.gen_inv_stage\[15\].inv/I
+ u_core.delay_paths.u_trc0.gen_inv_stage\[16\].inv/I VDD VDD VSS VSS gf180mcu_fd_sc_mcu7t5v0__inv_1
XTAP_TAPCELL_ROW_6_166 VDD VSS gf180mcu_fd_sc_mcu7t5v0__filltie
XFILLER_30_427 VDD VDD VSS VSS gf180mcu_fd_sc_mcu7t5v0__fill_2
XFILLER_12_91 VDD VDD VSS VSS gf180mcu_fd_sc_mcu7t5v0__fillcap_8
XFILLER_6_111 VDD VDD VSS VSS gf180mcu_fd_sc_mcu7t5v0__fill_2
XFILLER_6_177 VDD VDD VSS VSS gf180mcu_fd_sc_mcu7t5v0__fillcap_16
XPHY_EDGE_ROW_25_Left_86 VDD VSS gf180mcu_fd_sc_mcu7t5v0__endcap
XTAP_TAPCELL_ROW_3_147 VDD VSS gf180mcu_fd_sc_mcu7t5v0__filltie
XFILLER_47_346 VDD VDD VSS VSS gf180mcu_fd_sc_mcu7t5v0__fillcap_4
XFILLER_15_254 VDD VDD VSS VSS gf180mcu_fd_sc_mcu7t5v0__fillcap_4
XTAP_TAPCELL_ROW_25_282 VDD VSS gf180mcu_fd_sc_mcu7t5v0__filltie
Xu_core.delay_paths.u_trc0.gen_inv_stage\[7\].inv u_core.delay_paths.u_trc0.gen_inv_stage\[7\].inv/I
+ u_core.delay_paths.u_trc0.gen_inv_stage\[8\].inv/I VDD VDD VSS VSS gf180mcu_fd_sc_mcu7t5v0__inv_2
XFILLER_17_2 VDD VDD VSS VSS gf180mcu_fd_sc_mcu7t5v0__fillcap_64
XFILLER_38_357 VDD VDD VSS VSS gf180mcu_fd_sc_mcu7t5v0__fillcap_16
XFILLER_21_246 VDD VDD VSS VSS gf180mcu_fd_sc_mcu7t5v0__fillcap_4
Xu_core.delay_paths.u_trc2.gen_inv_stage\[6\].inv u_core.delay_paths.u_trc2.gen_inv_stage\[6\].inv/I
+ u_core.delay_paths.u_trc2.gen_inv_stage\[7\].inv/I VDD VDD VSS VSS gf180mcu_fd_sc_mcu7t5v0__inv_1
XTAP_TAPCELL_ROW_0_128 VDD VSS gf180mcu_fd_sc_mcu7t5v0__filltie
XFILLER_21_279 VDD VDD VSS VSS gf180mcu_fd_sc_mcu7t5v0__fill_1
XFILLER_29_368 VDD VDD VSS VSS gf180mcu_fd_sc_mcu7t5v0__fillcap_8
XFILLER_44_34 VDD VDD VSS VSS gf180mcu_fd_sc_mcu7t5v0__fill_1
XTAP_TAPCELL_ROW_39_363 VDD VSS gf180mcu_fd_sc_mcu7t5v0__filltie
XFILLER_44_45 VDD VDD VSS VSS gf180mcu_fd_sc_mcu7t5v0__fillcap_4
XFILLER_60_33 VDD VDD VSS VSS gf180mcu_fd_sc_mcu7t5v0__fill_1
XFILLER_8_206 VDD VDD VSS VSS gf180mcu_fd_sc_mcu7t5v0__fillcap_8
XTAP_TAPCELL_ROW_22_263 VDD VSS gf180mcu_fd_sc_mcu7t5v0__filltie
XFILLER_47_121 VDD VDD VSS VSS gf180mcu_fd_sc_mcu7t5v0__fillcap_8
X_687_ _687_/D _687_/RN _704_/CLK _687_/Q VDD VDD VSS VSS gf180mcu_fd_sc_mcu7t5v0__dffrnq_1
XTAP_TAPCELL_ROW_45_399 VDD VSS gf180mcu_fd_sc_mcu7t5v0__filltie
XFILLER_11_290 VDD VDD VSS VSS gf180mcu_fd_sc_mcu7t5v0__fillcap_4
XFILLER_58_419 VDD VDD VSS VSS gf180mcu_fd_sc_mcu7t5v0__fillcap_8
XFILLER_7_294 VDD VDD VSS VSS gf180mcu_fd_sc_mcu7t5v0__fill_1
XPHY_EDGE_ROW_7_Right_7 VDD VSS gf180mcu_fd_sc_mcu7t5v0__endcap
XTAP_TAPCELL_ROW_36_344 VDD VSS gf180mcu_fd_sc_mcu7t5v0__filltie
XFILLER_14_37 VDD VDD VSS VSS gf180mcu_fd_sc_mcu7t5v0__fillcap_32
XFILLER_1_415 VDD VDD VSS VSS gf180mcu_fd_sc_mcu7t5v0__fillcap_4
XPHY_EDGE_ROW_12_Left_73 VDD VSS gf180mcu_fd_sc_mcu7t5v0__endcap
XFILLER_29_121 VDD VDD VSS VSS gf180mcu_fd_sc_mcu7t5v0__fillcap_4
XFILLER_29_132 VDD VDD VSS VSS gf180mcu_fd_sc_mcu7t5v0__fillcap_8
XFILLER_39_67 VDD VDD VSS VSS gf180mcu_fd_sc_mcu7t5v0__fill_2
X_610_ _610_/D wire28/Z _700_/CLK _724_/I VDD VDD VSS VSS gf180mcu_fd_sc_mcu7t5v0__dffrnq_1
XFILLER_44_124 VDD VDD VSS VSS gf180mcu_fd_sc_mcu7t5v0__fill_2
XFILLER_55_66 VDD VDD VSS VSS gf180mcu_fd_sc_mcu7t5v0__fillcap_4
X_541_ _650_/Q _656_/Q _696_/D _650_/D VDD VDD VSS VSS gf180mcu_fd_sc_mcu7t5v0__mux2_2
X_472_ _472_/A1 _411_/C _483_/A1 _472_/B _664_/D VDD VDD VSS VSS gf180mcu_fd_sc_mcu7t5v0__oai31_1
XTAP_TAPCELL_ROW_58_480 VDD VSS gf180mcu_fd_sc_mcu7t5v0__filltie
XFILLER_31_341 VDD VDD VSS VSS gf180mcu_fd_sc_mcu7t5v0__fillcap_4
Xu_core.delay_paths.u_trc2.gen_inv_stage\[92\].inv u_core.delay_paths.u_trc2.gen_inv_stage\[92\].inv/I
+ u_core.delay_paths.u_trc2.gen_inv_stage\[93\].inv/I VDD VDD VSS VSS gf180mcu_fd_sc_mcu7t5v0__inv_1
Xwire7 wire7/I oINTERRUPT_OUT VDD VDD VSS VSS gf180mcu_fd_sc_mcu7t5v0__clkbuf_3
XFILLER_14_308 VDD VDD VSS VSS gf180mcu_fd_sc_mcu7t5v0__fillcap_4
XFILLER_26_157 VDD VDD VSS VSS gf180mcu_fd_sc_mcu7t5v0__fill_2
Xu_core.delay_paths.u_trc2.gen_inv_stage\[30\].inv u_core.delay_paths.u_trc2.gen_inv_stage\[30\].inv/I
+ u_core.delay_paths.u_trc2.gen_inv_stage\[31\].inv/I VDD VDD VSS VSS gf180mcu_fd_sc_mcu7t5v0__inv_1
Xu_core.delay_paths.u_trc2.gen_inv_stage\[45\].inv u_core.delay_paths.u_trc2.gen_inv_stage\[45\].inv/I
+ u_core.delay_paths.u_trc2.gen_inv_stage\[46\].inv/I VDD VDD VSS VSS gf180mcu_fd_sc_mcu7t5v0__inv_1
XFILLER_22_341 VDD VDD VSS VSS gf180mcu_fd_sc_mcu7t5v0__fillcap_16
XFILLER_1_212 VDD VDD VSS VSS gf180mcu_fd_sc_mcu7t5v0__fillcap_32
XFILLER_45_422 VDD VDD VSS VSS gf180mcu_fd_sc_mcu7t5v0__fillcap_8
XFILLER_57_282 VDD VDD VSS VSS gf180mcu_fd_sc_mcu7t5v0__fillcap_64
X_524_ _642_/Q _527_/A2 _525_/B VDD VDD VSS VSS gf180mcu_fd_sc_mcu7t5v0__nor2_1
X_455_ _691_/Q _455_/A2 _456_/B2 VDD VDD VSS VSS gf180mcu_fd_sc_mcu7t5v0__nand2_1
X_386_ _420_/A1 _421_/C _422_/A1 VDD VDD VSS VSS gf180mcu_fd_sc_mcu7t5v0__nand2_1
XTAP_TAPCELL_ROW_55_461 VDD VSS gf180mcu_fd_sc_mcu7t5v0__filltie
Xtrc_top_53 oSPI_MISO_SL VDD VDD VSS VSS gf180mcu_fd_sc_mcu7t5v0__tiel
XFILLER_9_356 VDD VDD VSS VSS gf180mcu_fd_sc_mcu7t5v0__fillcap_8
Xu_core.delay_paths.u_trc1.gen_inv_stage\[132\].inv u_core.delay_paths.u_trc1.gen_inv_stage\[132\].inv/I
+ u_core.delay_paths.u_trc1.gen_inv_stage\[133\].inv/I VDD VDD VSS VSS gf180mcu_fd_sc_mcu7t5v0__inv_1
XFILLER_27_422 VDD VDD VSS VSS gf180mcu_fd_sc_mcu7t5v0__fillcap_8
XFILLER_14_127 VDD VDD VSS VSS gf180mcu_fd_sc_mcu7t5v0__fill_1
XFILLER_36_57 VDD VDD VSS VSS gf180mcu_fd_sc_mcu7t5v0__fill_2
XFILLER_36_68 VDD VDD VSS VSS gf180mcu_fd_sc_mcu7t5v0__fillcap_8
XFILLER_52_34 VDD VDD VSS VSS gf180mcu_fd_sc_mcu7t5v0__fill_1
XFILLER_54_241 VDD VDD VSS VSS gf180mcu_fd_sc_mcu7t5v0__fillcap_4
XTAP_TAPCELL_ROW_52_442 VDD VSS gf180mcu_fd_sc_mcu7t5v0__filltie
XTAP_TAPCELL_ROW_9_186 VDD VSS gf180mcu_fd_sc_mcu7t5v0__filltie
XFILLER_37_208 VDD VDD VSS VSS gf180mcu_fd_sc_mcu7t5v0__fill_2
XFILLER_45_252 VDD VDD VSS VSS gf180mcu_fd_sc_mcu7t5v0__fillcap_16
XFILLER_60_244 VDD VDD VSS VSS gf180mcu_fd_sc_mcu7t5v0__fill_1
X_507_ _507_/A1 _509_/S _507_/B _680_/D VDD VDD VSS VSS gf180mcu_fd_sc_mcu7t5v0__oai21_1
X_438_ _695_/Q _694_/Q _448_/B1 VDD VDD VSS VSS gf180mcu_fd_sc_mcu7t5v0__nor2_1
X_369_ _374_/A2 _368_/Z _397_/C VDD VDD VSS VSS gf180mcu_fd_sc_mcu7t5v0__nor2_1
XFILLER_47_2 VDD VDD VSS VSS gf180mcu_fd_sc_mcu7t5v0__fillcap_64
XFILLER_3_72 VDD VDD VSS VSS gf180mcu_fd_sc_mcu7t5v0__fillcap_32
Xu_core.delay_paths.u_trc1.gen_inv_stage\[84\].inv u_core.delay_paths.u_trc1.gen_inv_stage\[84\].inv/I
+ u_core.delay_paths.u_trc1.gen_inv_stage\[85\].inv/I VDD VDD VSS VSS gf180mcu_fd_sc_mcu7t5v0__inv_1
XFILLER_36_263 VDD VDD VSS VSS gf180mcu_fd_sc_mcu7t5v0__fill_2
Xu_core.delay_paths.u_trc1.gen_inv_stage\[22\].inv u_core.delay_paths.u_trc1.gen_inv_stage\[22\].inv/I
+ u_core.delay_paths.u_trc1.gen_inv_stage\[23\].inv/I VDD VDD VSS VSS gf180mcu_fd_sc_mcu7t5v0__inv_1
Xu_core.delay_paths.u_trc1.gen_inv_stage\[99\].inv u_core.delay_paths.u_trc1.gen_inv_stage\[99\].inv/I
+ u_core.delay_paths.u_trc1.gen_inv_stage\[99\].inv/ZN VDD VDD VSS VSS gf180mcu_fd_sc_mcu7t5v0__inv_1
XFILLER_22_37 VDD VDD VSS VSS gf180mcu_fd_sc_mcu7t5v0__fillcap_32
Xu_core.delay_paths.u_trc1.gen_inv_stage\[37\].inv u_core.delay_paths.u_trc1.gen_inv_stage\[37\].inv/I
+ u_core.delay_paths.u_trc1.gen_inv_stage\[38\].inv/I VDD VDD VSS VSS gf180mcu_fd_sc_mcu7t5v0__inv_1
XTAP_TAPCELL_ROW_6_167 VDD VSS gf180mcu_fd_sc_mcu7t5v0__filltie
XFILLER_19_208 VDD VDD VSS VSS gf180mcu_fd_sc_mcu7t5v0__fill_2
XFILLER_10_141 VDD VDD VSS VSS gf180mcu_fd_sc_mcu7t5v0__fill_1
XFILLER_10_174 VDD VDD VSS VSS gf180mcu_fd_sc_mcu7t5v0__fill_1
XFILLER_10_185 VDD VDD VSS VSS gf180mcu_fd_sc_mcu7t5v0__fillcap_4
XFILLER_2_373 VDD VDD VSS VSS gf180mcu_fd_sc_mcu7t5v0__fillcap_4
XPHY_EDGE_ROW_0_Left_61 VDD VSS gf180mcu_fd_sc_mcu7t5v0__endcap
XTAP_TAPCELL_ROW_3_148 VDD VSS gf180mcu_fd_sc_mcu7t5v0__filltie
XFILLER_24_255 VDD VDD VSS VSS gf180mcu_fd_sc_mcu7t5v0__fillcap_4
XFILLER_24_299 VDD VDD VSS VSS gf180mcu_fd_sc_mcu7t5v0__fill_1
Xu_core.delay_paths.u_trc0.gen_inv_stage\[172\].inv u_core.delay_paths.u_trc0.gen_inv_stage\[172\].inv/I
+ u_core.delay_paths.u_trc0.gen_inv_stage\[173\].inv/I VDD VDD VSS VSS gf180mcu_fd_sc_mcu7t5v0__inv_1
XFILLER_3_104 VDD VDD VSS VSS gf180mcu_fd_sc_mcu7t5v0__fill_2
XFILLER_3_137 VDD VDD VSS VSS gf180mcu_fd_sc_mcu7t5v0__fill_2
Xu_core.delay_paths.u_trc0.gen_inv_stage\[187\].inv u_core.delay_paths.u_trc0.gen_inv_stage\[187\].inv/I
+ u_core.delay_paths.u_trc0.gen_inv_stage\[188\].inv/I VDD VDD VSS VSS gf180mcu_fd_sc_mcu7t5v0__inv_1
Xu_core.delay_paths.u_trc0.gen_inv_stage\[110\].inv u_core.delay_paths.u_trc0.gen_inv_stage\[110\].inv/I
+ u_core.delay_paths.u_trc0.gen_inv_stage\[111\].inv/I VDD VDD VSS VSS gf180mcu_fd_sc_mcu7t5v0__inv_2
XFILLER_15_277 VDD VDD VSS VSS gf180mcu_fd_sc_mcu7t5v0__fill_2
Xu_core.delay_paths.u_trc0.gen_inv_stage\[125\].inv u_core.delay_paths.u_trc0.gen_inv_stage\[125\].inv/I
+ u_core.delay_paths.u_trc0.gen_inv_stage\[126\].inv/I VDD VDD VSS VSS gf180mcu_fd_sc_mcu7t5v0__inv_2
XTAP_TAPCELL_ROW_25_283 VDD VSS gf180mcu_fd_sc_mcu7t5v0__filltie
Xu_core.delay_paths.u_trc0.gen_inv_stage\[61\].inv u_core.delay_paths.u_trc0.gen_inv_stage\[61\].inv/I
+ u_core.delay_paths.u_trc0.gen_inv_stage\[62\].inv/I VDD VDD VSS VSS gf180mcu_fd_sc_mcu7t5v0__inv_1
XTAP_TAPCELL_ROW_0_129 VDD VSS gf180mcu_fd_sc_mcu7t5v0__filltie
Xu_core.delay_paths.u_trc0.gen_inv_stage\[76\].inv u_core.delay_paths.u_trc0.gen_inv_stage\[76\].inv/I
+ u_core.delay_paths.u_trc0.gen_inv_stage\[77\].inv/I VDD VDD VSS VSS gf180mcu_fd_sc_mcu7t5v0__inv_2
Xu_core.delay_paths.u_trc0.gen_inv_stage\[14\].inv u_core.delay_paths.u_trc0.gen_inv_stage\[14\].inv/I
+ u_core.delay_paths.u_trc0.gen_inv_stage\[15\].inv/I VDD VDD VSS VSS gf180mcu_fd_sc_mcu7t5v0__inv_1
XFILLER_0_118 VDD VDD VSS VSS gf180mcu_fd_sc_mcu7t5v0__fill_2
XFILLER_29_336 VDD VDD VSS VSS gf180mcu_fd_sc_mcu7t5v0__fill_2
Xu_core.delay_paths.u_trc0.gen_inv_stage\[29\].inv u_core.delay_paths.u_trc0.gen_inv_stage\[29\].inv/I
+ u_core.delay_paths.u_trc0.gen_inv_stage\[30\].inv/I VDD VDD VSS VSS gf180mcu_fd_sc_mcu7t5v0__inv_1
XFILLER_44_317 VDD VDD VSS VSS gf180mcu_fd_sc_mcu7t5v0__fillcap_64
XFILLER_56_177 VDD VDD VSS VSS gf180mcu_fd_sc_mcu7t5v0__fillcap_64
XTAP_TAPCELL_ROW_39_364 VDD VSS gf180mcu_fd_sc_mcu7t5v0__filltie
XFILLER_12_247 VDD VDD VSS VSS gf180mcu_fd_sc_mcu7t5v0__fill_2
XFILLER_8_218 VDD VDD VSS VSS gf180mcu_fd_sc_mcu7t5v0__fill_1
XTAP_TAPCELL_ROW_22_264 VDD VSS gf180mcu_fd_sc_mcu7t5v0__filltie
XFILLER_4_413 VDD VDD VSS VSS gf180mcu_fd_sc_mcu7t5v0__fill_1
XFILLER_47_133 VDD VDD VSS VSS gf180mcu_fd_sc_mcu7t5v0__fill_1
X_686_ _686_/D _686_/RN _702_/CLK _686_/Q VDD VDD VSS VSS gf180mcu_fd_sc_mcu7t5v0__dffrnq_1
XFILLER_7_240 VDD VDD VSS VSS gf180mcu_fd_sc_mcu7t5v0__fillcap_8
XFILLER_19_391 VDD VDD VSS VSS gf180mcu_fd_sc_mcu7t5v0__fill_1
XFILLER_26_317 VDD VDD VSS VSS gf180mcu_fd_sc_mcu7t5v0__fill_1
XFILLER_34_350 VDD VDD VSS VSS gf180mcu_fd_sc_mcu7t5v0__fill_2
XFILLER_38_177 VDD VDD VSS VSS gf180mcu_fd_sc_mcu7t5v0__fillcap_16
XFILLER_38_199 VDD VDD VSS VSS gf180mcu_fd_sc_mcu7t5v0__fill_1
XFILLER_53_136 VDD VDD VSS VSS gf180mcu_fd_sc_mcu7t5v0__fillcap_4
XTAP_TAPCELL_ROW_36_345 VDD VSS gf180mcu_fd_sc_mcu7t5v0__filltie
XFILLER_30_37 VDD VDD VSS VSS gf180mcu_fd_sc_mcu7t5v0__fillcap_16
Xu_core.delay_paths.u_trc0.gen_inv_stage\[6\].inv u_core.delay_paths.u_trc0.gen_inv_stage\[6\].inv/I
+ u_core.delay_paths.u_trc0.gen_inv_stage\[7\].inv/I VDD VDD VSS VSS gf180mcu_fd_sc_mcu7t5v0__inv_2
X_540_ _644_/Q _649_/Q _540_/S _649_/D VDD VDD VSS VSS gf180mcu_fd_sc_mcu7t5v0__mux2_2
XFILLER_44_147 VDD VDD VSS VSS gf180mcu_fd_sc_mcu7t5v0__fillcap_4
X_471_ _664_/Q _481_/B _472_/B VDD VDD VSS VSS gf180mcu_fd_sc_mcu7t5v0__nand2_1
XFILLER_4_243 VDD VDD VSS VSS gf180mcu_fd_sc_mcu7t5v0__fill_2
Xu_core.delay_paths.u_trc2.gen_inv_stage\[5\].inv u_core.delay_paths.u_trc2.gen_inv_stage\[5\].inv/I
+ u_core.delay_paths.u_trc2.gen_inv_stage\[6\].inv/I VDD VDD VSS VSS gf180mcu_fd_sc_mcu7t5v0__inv_1
XFILLER_35_158 VDD VDD VSS VSS gf180mcu_fd_sc_mcu7t5v0__fill_2
X_669_ _669_/D _677_/RN _669_/CLK _669_/Q VDD VDD VSS VSS gf180mcu_fd_sc_mcu7t5v0__dffrnq_1
XTAP_TAPCELL_ROW_58_481 VDD VSS gf180mcu_fd_sc_mcu7t5v0__filltie
XFILLER_31_320 VDD VDD VSS VSS gf180mcu_fd_sc_mcu7t5v0__fill_1
XFILLER_31_397 VDD VDD VSS VSS gf180mcu_fd_sc_mcu7t5v0__fillcap_16
XTAP_TAPCELL_ROW_33_326 VDD VSS gf180mcu_fd_sc_mcu7t5v0__filltie
XFILLER_6_61 VDD VDD VSS VSS gf180mcu_fd_sc_mcu7t5v0__fill_1
XFILLER_6_94 VDD VDD VSS VSS gf180mcu_fd_sc_mcu7t5v0__fillcap_8
XFILLER_22_331 VDD VDD VSS VSS gf180mcu_fd_sc_mcu7t5v0__fill_1
XFILLER_1_268 VDD VDD VSS VSS gf180mcu_fd_sc_mcu7t5v0__fillcap_4
XFILLER_49_206 VDD VDD VSS VSS gf180mcu_fd_sc_mcu7t5v0__fillcap_4
X_523_ _641_/Q _635_/Q _528_/S _635_/D VDD VDD VSS VSS gf180mcu_fd_sc_mcu7t5v0__mux2_2
XFILLER_40_161 VDD VDD VSS VSS gf180mcu_fd_sc_mcu7t5v0__fillcap_8
XFILLER_60_426 VDD VDD VSS VSS gf180mcu_fd_sc_mcu7t5v0__fillcap_4
X_454_ _454_/A1 _453_/B _454_/B1 _456_/B1 _632_/D VDD VDD VSS VSS gf180mcu_fd_sc_mcu7t5v0__aoi22_1
X_385_ _686_/Q _402_/A2 _385_/B _421_/C VDD VDD VSS VSS gf180mcu_fd_sc_mcu7t5v0__aoi21_1
XTAP_TAPCELL_ROW_55_462 VDD VSS gf180mcu_fd_sc_mcu7t5v0__filltie
Xtrc_top_54 oINTERRUPT_OE VDD VDD VSS VSS gf180mcu_fd_sc_mcu7t5v0__tieh
XTAP_TAPCELL_ROW_52_443 VDD VSS gf180mcu_fd_sc_mcu7t5v0__filltie
XFILLER_7_2 VDD VDD VSS VSS gf180mcu_fd_sc_mcu7t5v0__fillcap_64
XTAP_TAPCELL_ROW_9_187 VDD VSS gf180mcu_fd_sc_mcu7t5v0__filltie
Xu_core.delay_paths.u_trc2.gen_inv_stage\[91\].inv u_core.delay_paths.u_trc2.gen_inv_stage\[91\].inv/I
+ u_core.delay_paths.u_trc2.gen_inv_stage\[92\].inv/I VDD VDD VSS VSS gf180mcu_fd_sc_mcu7t5v0__inv_1
X_506_ _676_/Q _509_/S _507_/B VDD VDD VSS VSS gf180mcu_fd_sc_mcu7t5v0__nand2_1
XFILLER_13_161 VDD VDD VSS VSS gf180mcu_fd_sc_mcu7t5v0__fillcap_8
XFILLER_13_194 VDD VDD VSS VSS gf180mcu_fd_sc_mcu7t5v0__fillcap_4
X_437_ _519_/A1 _694_/Q _437_/Z VDD VDD VSS VSS gf180mcu_fd_sc_mcu7t5v0__and2_1
X_368_ _676_/Q _672_/Q _507_/A1 _368_/Z VDD VDD VSS VSS gf180mcu_fd_sc_mcu7t5v0__xor3_1
X_299_ _299_/I _544_/A1 VDD VDD VSS VSS gf180mcu_fd_sc_mcu7t5v0__clkinv_1
XFILLER_9_154 VDD VDD VSS VSS gf180mcu_fd_sc_mcu7t5v0__fill_2
XFILLER_9_121 VDD VDD VSS VSS gf180mcu_fd_sc_mcu7t5v0__fill_2
Xu_core.delay_paths.u_trc2.gen_inv_stage\[44\].inv u_core.delay_paths.u_trc2.gen_inv_stage\[44\].inv/I
+ u_core.delay_paths.u_trc2.gen_inv_stage\[45\].inv/I VDD VDD VSS VSS gf180mcu_fd_sc_mcu7t5v0__inv_1
Xu_core.delay_paths.u_trc2.gen_inv_stage\[59\].inv u_core.delay_paths.u_trc2.gen_inv_stage\[59\].inv/I
+ u_core.delay_paths.u_trc2.gen_inv_stage\[60\].inv/I VDD VDD VSS VSS gf180mcu_fd_sc_mcu7t5v0__inv_1
XFILLER_51_212 VDD VDD VSS VSS gf180mcu_fd_sc_mcu7t5v0__fillcap_64
Xclkbuf_4_12__f_iCLK clkbuf_0_iCLK/Z _704_/CLK VDD VDD VSS VSS gf180mcu_fd_sc_mcu7t5v0__clkbuf_16
XTAP_TAPCELL_ROW_6_168 VDD VSS gf180mcu_fd_sc_mcu7t5v0__filltie
XFILLER_15_426 VDD VDD VSS VSS gf180mcu_fd_sc_mcu7t5v0__fillcap_4
XFILLER_42_223 VDD VDD VSS VSS gf180mcu_fd_sc_mcu7t5v0__fillcap_8
XPHY_EDGE_ROW_29_Right_29 VDD VSS gf180mcu_fd_sc_mcu7t5v0__endcap
XFILLER_30_429 VDD VDD VSS VSS gf180mcu_fd_sc_mcu7t5v0__fill_1
XFILLER_42_256 VDD VDD VSS VSS gf180mcu_fd_sc_mcu7t5v0__fillcap_8
XFILLER_6_102 VDD VDD VSS VSS gf180mcu_fd_sc_mcu7t5v0__fill_2
XPHY_EDGE_ROW_38_Right_38 VDD VSS gf180mcu_fd_sc_mcu7t5v0__endcap
XFILLER_6_157 VDD VDD VSS VSS gf180mcu_fd_sc_mcu7t5v0__fillcap_16
Xu_core.delay_paths.u_trc1.gen_inv_stage\[131\].inv u_core.delay_paths.u_trc1.gen_inv_stage\[131\].inv/I
+ u_core.delay_paths.u_trc1.gen_inv_stage\[132\].inv/I VDD VDD VSS VSS gf180mcu_fd_sc_mcu7t5v0__inv_1
XPHY_EDGE_ROW_47_Right_47 VDD VSS gf180mcu_fd_sc_mcu7t5v0__endcap
XFILLER_18_297 VDD VDD VSS VSS gf180mcu_fd_sc_mcu7t5v0__fillcap_16
XFILLER_33_212 VDD VDD VSS VSS gf180mcu_fd_sc_mcu7t5v0__fill_2
XFILLER_33_278 VDD VDD VSS VSS gf180mcu_fd_sc_mcu7t5v0__fill_2
XPHY_EDGE_ROW_56_Right_56 VDD VSS gf180mcu_fd_sc_mcu7t5v0__endcap
XFILLER_5_190 VDD VDD VSS VSS gf180mcu_fd_sc_mcu7t5v0__fillcap_8
XTAP_TAPCELL_ROW_3_149 VDD VSS gf180mcu_fd_sc_mcu7t5v0__filltie
XFILLER_12_429 VDD VDD VSS VSS gf180mcu_fd_sc_mcu7t5v0__fill_1
XFILLER_58_34 VDD VDD VSS VSS gf180mcu_fd_sc_mcu7t5v0__fill_1
XFILLER_59_142 VDD VDD VSS VSS gf180mcu_fd_sc_mcu7t5v0__fillcap_64
XFILLER_7_422 VDD VDD VSS VSS gf180mcu_fd_sc_mcu7t5v0__fillcap_8
Xu_core.delay_paths.u_trc1.gen_inv_stage\[83\].inv u_core.delay_paths.u_trc1.gen_inv_stage\[83\].inv/I
+ u_core.delay_paths.u_trc1.gen_inv_stage\[84\].inv/I VDD VDD VSS VSS gf180mcu_fd_sc_mcu7t5v0__inv_1
Xu_core.delay_paths.u_trc1.gen_inv_stage\[21\].inv u_core.delay_paths.u_trc1.gen_inv_stage\[21\].inv/I
+ u_core.delay_paths.u_trc1.gen_inv_stage\[22\].inv/I VDD VDD VSS VSS gf180mcu_fd_sc_mcu7t5v0__inv_1
Xu_core.delay_paths.u_trc1.gen_inv_stage\[98\].inv u_core.delay_paths.u_trc1.gen_inv_stage\[98\].inv/I
+ u_core.delay_paths.u_trc1.gen_inv_stage\[99\].inv/I VDD VDD VSS VSS gf180mcu_fd_sc_mcu7t5v0__inv_1
XFILLER_0_52 VDD VDD VSS VSS gf180mcu_fd_sc_mcu7t5v0__fill_1
XFILLER_46_381 VDD VDD VSS VSS gf180mcu_fd_sc_mcu7t5v0__fillcap_4
Xu_core.delay_paths.u_trc1.gen_inv_stage\[36\].inv u_core.delay_paths.u_trc1.gen_inv_stage\[36\].inv/I
+ u_core.delay_paths.u_trc1.gen_inv_stage\[37\].inv/I VDD VDD VSS VSS gf180mcu_fd_sc_mcu7t5v0__inv_1
XFILLER_9_72 VDD VDD VSS VSS gf180mcu_fd_sc_mcu7t5v0__fillcap_16
XFILLER_28_37 VDD VDD VSS VSS gf180mcu_fd_sc_mcu7t5v0__fillcap_16
XFILLER_56_101 VDD VDD VSS VSS gf180mcu_fd_sc_mcu7t5v0__fillcap_4
XTAP_TAPCELL_ROW_39_365 VDD VSS gf180mcu_fd_sc_mcu7t5v0__filltie
XTAP_TAPCELL_ROW_22_265 VDD VSS gf180mcu_fd_sc_mcu7t5v0__filltie
X_685_ _685_/D _685_/RN _685_/CLK _685_/Q VDD VDD VSS VSS gf180mcu_fd_sc_mcu7t5v0__dffrnq_1
XFILLER_34_80 VDD VDD VSS VSS gf180mcu_fd_sc_mcu7t5v0__fillcap_8
XTAP_TAPCELL_ROW_13_210 VDD VSS gf180mcu_fd_sc_mcu7t5v0__filltie
XFILLER_22_2 VDD VDD VSS VSS gf180mcu_fd_sc_mcu7t5v0__fillcap_32
Xu_core.delay_paths.u_trc0.gen_inv_stage\[171\].inv u_core.delay_paths.u_trc0.gen_inv_stage\[171\].inv/I
+ u_core.delay_paths.u_trc0.gen_inv_stage\[172\].inv/I VDD VDD VSS VSS gf180mcu_fd_sc_mcu7t5v0__inv_1
XFILLER_34_384 VDD VDD VSS VSS gf180mcu_fd_sc_mcu7t5v0__fill_1
Xu_core.delay_paths.u_trc0.gen_inv_stage\[186\].inv u_core.delay_paths.u_trc0.gen_inv_stage\[186\].inv/I
+ u_core.delay_paths.u_trc0.gen_inv_stage\[187\].inv/I VDD VDD VSS VSS gf180mcu_fd_sc_mcu7t5v0__inv_1
XTAP_TAPCELL_ROW_36_346 VDD VSS gf180mcu_fd_sc_mcu7t5v0__filltie
XPHY_EDGE_ROW_46_Left_107 VDD VSS gf180mcu_fd_sc_mcu7t5v0__endcap
Xu_core.delay_paths.u_trc0.gen_inv_stage\[124\].inv u_core.delay_paths.u_trc0.gen_inv_stage\[124\].inv/I
+ u_core.delay_paths.u_trc0.gen_inv_stage\[125\].inv/I VDD VDD VSS VSS gf180mcu_fd_sc_mcu7t5v0__inv_2
Xu_core.delay_paths.u_trc0.gen_inv_stage\[139\].inv u_core.delay_paths.u_trc0.gen_inv_stage\[139\].inv/I
+ u_core.delay_paths.u_trc0.gen_inv_stage\[140\].inv/I VDD VDD VSS VSS gf180mcu_fd_sc_mcu7t5v0__inv_1
XPHY_EDGE_ROW_55_Left_116 VDD VSS gf180mcu_fd_sc_mcu7t5v0__endcap
XFILLER_39_69 VDD VDD VSS VSS gf180mcu_fd_sc_mcu7t5v0__fill_1
XFILLER_40_321 VDD VDD VSS VSS gf180mcu_fd_sc_mcu7t5v0__fill_2
XFILLER_40_387 VDD VDD VSS VSS gf180mcu_fd_sc_mcu7t5v0__fillcap_32
X_470_ _663_/Q _483_/A1 _470_/B _663_/D VDD VDD VSS VSS gf180mcu_fd_sc_mcu7t5v0__oai21_1
Xu_core.delay_paths.u_trc0.gen_inv_stage\[60\].inv u_core.delay_paths.u_trc0.gen_inv_stage\[60\].inv/I
+ u_core.delay_paths.u_trc0.gen_inv_stage\[61\].inv/I VDD VDD VSS VSS gf180mcu_fd_sc_mcu7t5v0__inv_1
XFILLER_20_93 VDD VDD VSS VSS gf180mcu_fd_sc_mcu7t5v0__fillcap_4
Xu_core.delay_paths.u_trc0.gen_inv_stage\[75\].inv u_core.delay_paths.u_trc0.gen_inv_stage\[75\].inv/I
+ u_core.delay_paths.u_trc0.gen_inv_stage\[76\].inv/I VDD VDD VSS VSS gf180mcu_fd_sc_mcu7t5v0__inv_1
XFILLER_50_107 VDD VDD VSS VSS gf180mcu_fd_sc_mcu7t5v0__fillcap_64
Xu_core.delay_paths.u_trc0.gen_inv_stage\[13\].inv u_core.delay_paths.u_trc0.gen_inv_stage\[13\].inv/I
+ u_core.delay_paths.u_trc0.gen_inv_stage\[14\].inv/I VDD VDD VSS VSS gf180mcu_fd_sc_mcu7t5v0__inv_1
X_668_ _668_/D wire28/Z _669_/CLK _668_/Q VDD VDD VSS VSS gf180mcu_fd_sc_mcu7t5v0__dffrnq_1
X_599_ _601_/I _630_/RN VDD VDD VSS VSS gf180mcu_fd_sc_mcu7t5v0__clkinv_1
XTAP_TAPCELL_ROW_33_327 VDD VSS gf180mcu_fd_sc_mcu7t5v0__filltie
XFILLER_31_365 VDD VDD VSS VSS gf180mcu_fd_sc_mcu7t5v0__fillcap_32
Xu_core.delay_paths.u_trc0.gen_inv_stage\[28\].inv u_core.delay_paths.u_trc0.gen_inv_stage\[28\].inv/I
+ u_core.delay_paths.u_trc0.gen_inv_stage\[29\].inv/I VDD VDD VSS VSS gf180mcu_fd_sc_mcu7t5v0__inv_1
XFILLER_22_310 VDD VDD VSS VSS gf180mcu_fd_sc_mcu7t5v0__fill_1
XFILLER_22_321 VDD VDD VSS VSS gf180mcu_fd_sc_mcu7t5v0__fillcap_4
XFILLER_17_104 VDD VDD VSS VSS gf180mcu_fd_sc_mcu7t5v0__fillcap_4
XFILLER_32_107 VDD VDD VSS VSS gf180mcu_fd_sc_mcu7t5v0__fillcap_4
X_522_ _522_/A1 _528_/S _522_/B _634_/D VDD VDD VSS VSS gf180mcu_fd_sc_mcu7t5v0__aoi21_1
X_453_ _639_/Q _437_/Z _453_/B _456_/B1 VDD VDD VSS VSS gf180mcu_fd_sc_mcu7t5v0__aoi21_1
XTAP_TAPCELL_ROW_55_463 VDD VSS gf180mcu_fd_sc_mcu7t5v0__filltie
XFILLER_13_310 VDD VDD VSS VSS gf180mcu_fd_sc_mcu7t5v0__fill_1
XFILLER_40_173 VDD VDD VSS VSS gf180mcu_fd_sc_mcu7t5v0__fill_2
X_384_ _384_/A1 _384_/A2 _384_/B _384_/C _385_/B VDD VDD VSS VSS gf180mcu_fd_sc_mcu7t5v0__oai211_1
XTAP_TAPCELL_ROW_30_308 VDD VSS gf180mcu_fd_sc_mcu7t5v0__filltie
XFILLER_31_92 VDD VDD VSS VSS gf180mcu_fd_sc_mcu7t5v0__fillcap_4
Xtrc_top_55 oSPI_MISO_OE VDD VDD VSS VSS gf180mcu_fd_sc_mcu7t5v0__tieh
XFILLER_51_416 VDD VDD VSS VSS gf180mcu_fd_sc_mcu7t5v0__fillcap_4
Xu_core.delay_paths.u_trc0.gen_inv_stage\[5\].inv u_core.delay_paths.u_trc0.gen_inv_stage\[5\].inv/I
+ u_core.delay_paths.u_trc0.gen_inv_stage\[6\].inv/I VDD VDD VSS VSS gf180mcu_fd_sc_mcu7t5v0__inv_1
XFILLER_8_380 VDD VDD VSS VSS gf180mcu_fd_sc_mcu7t5v0__fill_1
XFILLER_14_107 VDD VDD VSS VSS gf180mcu_fd_sc_mcu7t5v0__fillcap_16
XFILLER_36_37 VDD VDD VSS VSS gf180mcu_fd_sc_mcu7t5v0__fillcap_16
XFILLER_36_59 VDD VDD VSS VSS gf180mcu_fd_sc_mcu7t5v0__fill_1
XFILLER_42_427 VDD VDD VSS VSS gf180mcu_fd_sc_mcu7t5v0__fill_2
XFILLER_10_313 VDD VDD VSS VSS gf180mcu_fd_sc_mcu7t5v0__fill_2
XFILLER_10_335 VDD VDD VSS VSS gf180mcu_fd_sc_mcu7t5v0__fill_2
XFILLER_6_306 VDD VDD VSS VSS gf180mcu_fd_sc_mcu7t5v0__fillcap_4
XFILLER_6_317 VDD VDD VSS VSS gf180mcu_fd_sc_mcu7t5v0__fill_2
Xu_core.delay_paths.u_trc2.gen_inv_stage\[4\].inv u_core.delay_paths.u_trc2.gen_inv_stage\[4\].inv/I
+ u_core.delay_paths.u_trc2.gen_inv_stage\[5\].inv/I VDD VDD VSS VSS gf180mcu_fd_sc_mcu7t5v0__inv_1
XTAP_TAPCELL_ROW_52_444 VDD VSS gf180mcu_fd_sc_mcu7t5v0__filltie
XFILLER_45_276 VDD VDD VSS VSS gf180mcu_fd_sc_mcu7t5v0__fillcap_4
X_505_ _679_/Q _675_/Q _702_/D _679_/D VDD VDD VSS VSS gf180mcu_fd_sc_mcu7t5v0__mux2_2
X_436_ _519_/A1 _694_/Q _455_/A2 VDD VDD VSS VSS gf180mcu_fd_sc_mcu7t5v0__nor2_1
XFILLER_9_100 VDD VDD VSS VSS gf180mcu_fd_sc_mcu7t5v0__fill_1
X_367_ _676_/Q _672_/Q _389_/A2 VDD VDD VSS VSS gf180mcu_fd_sc_mcu7t5v0__nor2_1
X_298_ _703_/Q _346_/B VDD VDD VSS VSS gf180mcu_fd_sc_mcu7t5v0__clkinv_1
XFILLER_9_166 VDD VDD VSS VSS gf180mcu_fd_sc_mcu7t5v0__fillcap_16
XFILLER_5_372 VDD VDD VSS VSS gf180mcu_fd_sc_mcu7t5v0__fill_2
XFILLER_36_232 VDD VDD VSS VSS gf180mcu_fd_sc_mcu7t5v0__fill_1
Xu_core.delay_paths.u_trc3.gen_inv_stage\[19\].inv u_core.delay_paths.u_trc3.gen_inv_stage\[19\].inv/I
+ u_core.delay_paths.u_trc3.gen_inv_stage\[20\].inv/I VDD VDD VSS VSS gf180mcu_fd_sc_mcu7t5v0__inv_1
XFILLER_59_346 VDD VDD VSS VSS gf180mcu_fd_sc_mcu7t5v0__fillcap_4
XTAP_TAPCELL_ROW_6_169 VDD VSS gf180mcu_fd_sc_mcu7t5v0__filltie
XFILLER_30_419 VDD VDD VSS VSS gf180mcu_fd_sc_mcu7t5v0__fillcap_8
XFILLER_42_235 VDD VDD VSS VSS gf180mcu_fd_sc_mcu7t5v0__fill_1
XFILLER_42_268 VDD VDD VSS VSS gf180mcu_fd_sc_mcu7t5v0__fill_2
XFILLER_6_125 VDD VDD VSS VSS gf180mcu_fd_sc_mcu7t5v0__fillcap_32
XFILLER_33_246 VDD VDD VSS VSS gf180mcu_fd_sc_mcu7t5v0__fillcap_4
XFILLER_41_290 VDD VDD VSS VSS gf180mcu_fd_sc_mcu7t5v0__fillcap_8
X_419_ _639_/Q _421_/C _419_/Z VDD VDD VSS VSS gf180mcu_fd_sc_mcu7t5v0__and2_1
XFILLER_52_2 VDD VDD VSS VSS gf180mcu_fd_sc_mcu7t5v0__fillcap_32
XFILLER_3_106 VDD VDD VSS VSS gf180mcu_fd_sc_mcu7t5v0__fill_1
XFILLER_3_139 VDD VDD VSS VSS gf180mcu_fd_sc_mcu7t5v0__fill_1
Xu_core.delay_paths.u_trc2.gen_inv_stage\[90\].inv u_core.delay_paths.u_trc2.gen_inv_stage\[90\].inv/I
+ u_core.delay_paths.u_trc2.gen_inv_stage\[91\].inv/I VDD VDD VSS VSS gf180mcu_fd_sc_mcu7t5v0__inv_1
XFILLER_15_279 VDD VDD VSS VSS gf180mcu_fd_sc_mcu7t5v0__fill_1
XFILLER_30_238 VDD VDD VSS VSS gf180mcu_fd_sc_mcu7t5v0__fillcap_4
Xu_core.delay_paths.u_trc2.gen_inv_stage\[43\].inv u_core.delay_paths.u_trc2.gen_inv_stage\[43\].inv/I
+ u_core.delay_paths.u_trc2.gen_inv_stage\[44\].inv/I VDD VDD VSS VSS gf180mcu_fd_sc_mcu7t5v0__inv_1
Xu_core.delay_paths.u_trc2.gen_inv_stage\[58\].inv u_core.delay_paths.u_trc2.gen_inv_stage\[58\].inv/I
+ u_core.delay_paths.u_trc2.gen_inv_stage\[59\].inv/I VDD VDD VSS VSS gf180mcu_fd_sc_mcu7t5v0__inv_1
XFILLER_2_172 VDD VDD VSS VSS gf180mcu_fd_sc_mcu7t5v0__fill_2
XFILLER_44_308 VDD VDD VSS VSS gf180mcu_fd_sc_mcu7t5v0__fillcap_4
XTAP_TAPCELL_ROW_39_366 VDD VSS gf180mcu_fd_sc_mcu7t5v0__filltie
XFILLER_44_37 VDD VDD VSS VSS gf180mcu_fd_sc_mcu7t5v0__fillcap_8
Xu_core.delay_paths.u_trc1.gen_inv_stage\[130\].inv u_core.delay_paths.u_trc1.gen_inv_stage\[130\].inv/I
+ u_core.delay_paths.u_trc1.gen_inv_stage\[131\].inv/I VDD VDD VSS VSS gf180mcu_fd_sc_mcu7t5v0__inv_1
XFILLER_20_271 VDD VDD VSS VSS gf180mcu_fd_sc_mcu7t5v0__fillcap_4
XFILLER_60_36 VDD VDD VSS VSS gf180mcu_fd_sc_mcu7t5v0__fillcap_32
XFILLER_43_352 VDD VDD VSS VSS gf180mcu_fd_sc_mcu7t5v0__fillcap_64
X_684_ _684_/D _686_/RN _702_/CLK _684_/Q VDD VDD VSS VSS gf180mcu_fd_sc_mcu7t5v0__dffrnq_1
XFILLER_11_282 VDD VDD VSS VSS gf180mcu_fd_sc_mcu7t5v0__fillcap_8
XFILLER_7_220 VDD VDD VSS VSS gf180mcu_fd_sc_mcu7t5v0__fillcap_4
XTAP_TAPCELL_ROW_13_211 VDD VSS gf180mcu_fd_sc_mcu7t5v0__filltie
XFILLER_15_2 VDD VDD VSS VSS gf180mcu_fd_sc_mcu7t5v0__fillcap_64
XFILLER_26_308 VDD VDD VSS VSS gf180mcu_fd_sc_mcu7t5v0__fillcap_4
XFILLER_34_341 VDD VDD VSS VSS gf180mcu_fd_sc_mcu7t5v0__fill_2
XTAP_TAPCELL_ROW_36_347 VDD VSS gf180mcu_fd_sc_mcu7t5v0__filltie
XFILLER_1_407 VDD VDD VSS VSS gf180mcu_fd_sc_mcu7t5v0__fillcap_8
XFILLER_39_26 VDD VDD VSS VSS gf180mcu_fd_sc_mcu7t5v0__fillcap_4
XFILLER_37_190 VDD VDD VSS VSS gf180mcu_fd_sc_mcu7t5v0__fill_2
XFILLER_57_422 VDD VDD VSS VSS gf180mcu_fd_sc_mcu7t5v0__fillcap_8
Xu_core.delay_paths.u_trc1.gen_inv_stage\[82\].inv u_core.delay_paths.u_trc1.gen_inv_stage\[82\].inv/I
+ u_core.delay_paths.u_trc1.gen_inv_stage\[83\].inv/I VDD VDD VSS VSS gf180mcu_fd_sc_mcu7t5v0__inv_1
Xu_core.delay_paths.u_trc1.gen_inv_stage\[97\].inv u_core.delay_paths.u_trc1.gen_inv_stage\[97\].inv/I
+ u_core.delay_paths.u_trc1.gen_inv_stage\[98\].inv/I VDD VDD VSS VSS gf180mcu_fd_sc_mcu7t5v0__inv_1
XFILLER_40_311 VDD VDD VSS VSS gf180mcu_fd_sc_mcu7t5v0__fillcap_4
XFILLER_52_171 VDD VDD VSS VSS gf180mcu_fd_sc_mcu7t5v0__fillcap_4
Xu_core.delay_paths.u_trc1.gen_inv_stage\[20\].inv u_core.delay_paths.u_trc1.gen_inv_stage\[20\].inv/I
+ u_core.delay_paths.u_trc1.gen_inv_stage\[21\].inv/I VDD VDD VSS VSS gf180mcu_fd_sc_mcu7t5v0__inv_1
XFILLER_4_234 VDD VDD VSS VSS gf180mcu_fd_sc_mcu7t5v0__fill_1
XFILLER_4_267 VDD VDD VSS VSS gf180mcu_fd_sc_mcu7t5v0__fill_2
Xu_core.delay_paths.u_trc1.gen_inv_stage\[35\].inv u_core.delay_paths.u_trc1.gen_inv_stage\[35\].inv/I
+ u_core.delay_paths.u_trc1.gen_inv_stage\[36\].inv/I VDD VDD VSS VSS gf180mcu_fd_sc_mcu7t5v0__inv_1
XFILLER_29_92 VDD VDD VSS VSS gf180mcu_fd_sc_mcu7t5v0__fill_2
X_667_ _667_/D wire28/Z _669_/CLK _667_/Q VDD VDD VSS VSS gf180mcu_fd_sc_mcu7t5v0__dffrnq_1
X_598_ _602_/I _629_/RN VDD VDD VSS VSS gf180mcu_fd_sc_mcu7t5v0__clkinv_1
XTAP_TAPCELL_ROW_33_328 VDD VSS gf180mcu_fd_sc_mcu7t5v0__filltie
XFILLER_39_422 VDD VDD VSS VSS gf180mcu_fd_sc_mcu7t5v0__fillcap_8
XPHY_EDGE_ROW_16_Left_77 VDD VSS gf180mcu_fd_sc_mcu7t5v0__endcap
XFILLER_22_300 VDD VDD VSS VSS gf180mcu_fd_sc_mcu7t5v0__fillcap_8
X_521_ _640_/Q _528_/S _522_/B VDD VDD VSS VSS gf180mcu_fd_sc_mcu7t5v0__nor2_1
X_452_ _690_/Q _455_/A2 _454_/B1 VDD VDD VSS VSS gf180mcu_fd_sc_mcu7t5v0__nand2_1
X_383_ _682_/Q _384_/A1 _380_/Z _402_/A2 VDD VDD VSS VSS gf180mcu_fd_sc_mcu7t5v0__xnor3_1
XFILLER_15_72 VDD VDD VSS VSS gf180mcu_fd_sc_mcu7t5v0__fillcap_16
XFILLER_40_141 VDD VDD VSS VSS gf180mcu_fd_sc_mcu7t5v0__fillcap_4
XFILLER_40_185 VDD VDD VSS VSS gf180mcu_fd_sc_mcu7t5v0__fill_1
Xu_core.delay_paths.u_trc0.gen_inv_stage\[170\].inv u_core.delay_paths.u_trc0.gen_inv_stage\[170\].inv/I
+ u_core.delay_paths.u_trc0.gen_inv_stage\[171\].inv/I VDD VDD VSS VSS gf180mcu_fd_sc_mcu7t5v0__inv_1
XTAP_TAPCELL_ROW_30_309 VDD VSS gf180mcu_fd_sc_mcu7t5v0__filltie
Xu_core.delay_paths.u_trc0.gen_inv_stage\[185\].inv u_core.delay_paths.u_trc0.gen_inv_stage\[185\].inv/I
+ u_core.delay_paths.u_trc0.gen_inv_stage\[186\].inv/I VDD VDD VSS VSS gf180mcu_fd_sc_mcu7t5v0__inv_1
Xtrc_top_45 oINTERRUPT_IE VDD VDD VSS VSS gf180mcu_fd_sc_mcu7t5v0__tiel
XFILLER_48_241 VDD VDD VSS VSS gf180mcu_fd_sc_mcu7t5v0__fillcap_4
Xu_core.delay_paths.u_trc0.gen_inv_stage\[123\].inv u_core.delay_paths.u_trc0.gen_inv_stage\[123\].inv/I
+ u_core.delay_paths.u_trc0.gen_inv_stage\[124\].inv/I VDD VDD VSS VSS gf180mcu_fd_sc_mcu7t5v0__clkinv_1
X_719_ _719_/I _719_/Z VDD VDD VSS VSS gf180mcu_fd_sc_mcu7t5v0__buf_1
Xu_core.delay_paths.u_trc0.gen_inv_stage\[138\].inv u_core.delay_paths.u_trc0.gen_inv_stage\[138\].inv/I
+ u_core.delay_paths.u_trc0.gen_inv_stage\[139\].inv/I VDD VDD VSS VSS gf180mcu_fd_sc_mcu7t5v0__inv_1
Xu_core.delay_paths.u_trc0.gen_inv_stage\[74\].inv u_core.delay_paths.u_trc0.gen_inv_stage\[74\].inv/I
+ u_core.delay_paths.u_trc0.gen_inv_stage\[75\].inv/I VDD VDD VSS VSS gf180mcu_fd_sc_mcu7t5v0__inv_1
XFILLER_10_325 VDD VDD VSS VSS gf180mcu_fd_sc_mcu7t5v0__fill_2
XFILLER_52_37 VDD VDD VSS VSS gf180mcu_fd_sc_mcu7t5v0__fillcap_64
Xu_core.delay_paths.u_trc0.gen_inv_stage\[89\].inv u_core.delay_paths.u_trc0.gen_inv_stage\[89\].inv/I
+ u_core.delay_paths.u_trc0.gen_inv_stage\[90\].inv/I VDD VDD VSS VSS gf180mcu_fd_sc_mcu7t5v0__inv_2
XTAP_TAPCELL_ROW_52_445 VDD VSS gf180mcu_fd_sc_mcu7t5v0__filltie
Xu_core.delay_paths.u_trc0.gen_inv_stage\[12\].inv u_core.delay_paths.u_trc0.gen_inv_stage\[12\].inv/I
+ u_core.delay_paths.u_trc0.gen_inv_stage\[13\].inv/I VDD VDD VSS VSS gf180mcu_fd_sc_mcu7t5v0__inv_1
XFILLER_45_200 VDD VDD VSS VSS gf180mcu_fd_sc_mcu7t5v0__fill_2
XFILLER_45_244 VDD VDD VSS VSS gf180mcu_fd_sc_mcu7t5v0__fillcap_4
Xu_core.delay_paths.u_trc0.gen_inv_stage\[27\].inv u_core.delay_paths.u_trc0.gen_inv_stage\[27\].inv/I
+ u_core.delay_paths.u_trc0.gen_inv_stage\[28\].inv/I VDD VDD VSS VSS gf180mcu_fd_sc_mcu7t5v0__inv_1
XFILLER_26_93 VDD VDD VSS VSS gf180mcu_fd_sc_mcu7t5v0__fillcap_4
XFILLER_60_269 VDD VDD VSS VSS gf180mcu_fd_sc_mcu7t5v0__fill_2
X_504_ _678_/Q _674_/Q _504_/S _678_/D VDD VDD VSS VSS gf180mcu_fd_sc_mcu7t5v0__mux2_2
X_435_ _624_/Q _623_/D _625_/Q _435_/Z VDD VDD VSS VSS gf180mcu_fd_sc_mcu7t5v0__or3_1
X_366_ _676_/Q _672_/Q _389_/B VDD VDD VSS VSS gf180mcu_fd_sc_mcu7t5v0__nand2_1
XFILLER_9_123 VDD VDD VSS VSS gf180mcu_fd_sc_mcu7t5v0__fill_1
X_297_ _704_/Q _351_/A1 VDD VDD VSS VSS gf180mcu_fd_sc_mcu7t5v0__clkinv_1
XFILLER_9_156 VDD VDD VSS VSS gf180mcu_fd_sc_mcu7t5v0__fill_1
XFILLER_42_247 VDD VDD VSS VSS gf180mcu_fd_sc_mcu7t5v0__fill_2
XPHY_EDGE_ROW_19_Left_80 VDD VSS gf180mcu_fd_sc_mcu7t5v0__endcap
XFILLER_10_133 VDD VDD VSS VSS gf180mcu_fd_sc_mcu7t5v0__fillcap_8
XFILLER_10_177 VDD VDD VSS VSS gf180mcu_fd_sc_mcu7t5v0__fillcap_8
XFILLER_6_104 VDD VDD VSS VSS gf180mcu_fd_sc_mcu7t5v0__fill_1
Xclkbuf_4_6__f_iCLK clkbuf_0_iCLK/Z _699_/CLK VDD VDD VSS VSS gf180mcu_fd_sc_mcu7t5v0__clkbuf_16
Xu_core.delay_paths.u_trc0.gen_inv_stage\[4\].inv u_core.delay_paths.u_trc0.gen_inv_stage\[4\].inv/I
+ u_core.delay_paths.u_trc0.gen_inv_stage\[5\].inv/I VDD VDD VSS VSS gf180mcu_fd_sc_mcu7t5v0__inv_1
X_418_ _420_/A4 _418_/A2 _418_/B _423_/A1 VDD VDD VSS VSS gf180mcu_fd_sc_mcu7t5v0__oai21_1
X_349_ _349_/A1 _349_/A2 _349_/Z VDD VDD VSS VSS gf180mcu_fd_sc_mcu7t5v0__and2_1
XFILLER_45_2 VDD VDD VSS VSS gf180mcu_fd_sc_mcu7t5v0__fillcap_32
XTAP_TAPCELL_ROW_11_194 VDD VSS gf180mcu_fd_sc_mcu7t5v0__filltie
XFILLER_56_317 VDD VDD VSS VSS gf180mcu_fd_sc_mcu7t5v0__fillcap_64
Xu_core.delay_paths.u_trc2.gen_inv_stage\[3\].inv u_core.delay_paths.u_trc2.gen_inv_stage\[3\].inv/I
+ u_core.delay_paths.u_trc2.gen_inv_stage\[4\].inv/I VDD VDD VSS VSS gf180mcu_fd_sc_mcu7t5v0__inv_1
XFILLER_24_247 VDD VDD VSS VSS gf180mcu_fd_sc_mcu7t5v0__fillcap_8
XFILLER_3_129 VDD VDD VSS VSS gf180mcu_fd_sc_mcu7t5v0__fillcap_8
XFILLER_15_203 VDD VDD VSS VSS gf180mcu_fd_sc_mcu7t5v0__fillcap_4
XTAP_TAPCELL_ROW_2_140 VDD VSS gf180mcu_fd_sc_mcu7t5v0__filltie
XFILLER_23_72 VDD VDD VSS VSS gf180mcu_fd_sc_mcu7t5v0__fillcap_4
XPHY_EDGE_ROW_4_Left_65 VDD VSS gf180mcu_fd_sc_mcu7t5v0__endcap
Xu_core.delay_paths.u_trc3.gen_inv_stage\[18\].inv u_core.delay_paths.u_trc3.gen_inv_stage\[18\].inv/I
+ u_core.delay_paths.u_trc3.gen_inv_stage\[19\].inv/I VDD VDD VSS VSS gf180mcu_fd_sc_mcu7t5v0__inv_1
XTAP_TAPCELL_ROW_39_367 VDD VSS gf180mcu_fd_sc_mcu7t5v0__filltie
XFILLER_12_206 VDD VDD VSS VSS gf180mcu_fd_sc_mcu7t5v0__fillcap_4
XFILLER_44_49 VDD VDD VSS VSS gf180mcu_fd_sc_mcu7t5v0__fill_1
X_683_ _683_/D _700_/RN _705_/CLK _683_/Q VDD VDD VSS VSS gf180mcu_fd_sc_mcu7t5v0__dffrnq_1
XFILLER_7_276 VDD VDD VSS VSS gf180mcu_fd_sc_mcu7t5v0__fillcap_4
XFILLER_34_364 VDD VDD VSS VSS gf180mcu_fd_sc_mcu7t5v0__fillcap_16
XTAP_TAPCELL_ROW_44_392 VDD VSS gf180mcu_fd_sc_mcu7t5v0__filltie
XTAP_TAPCELL_ROW_36_348 VDD VSS gf180mcu_fd_sc_mcu7t5v0__filltie
XFILLER_1_419 VDD VDD VSS VSS gf180mcu_fd_sc_mcu7t5v0__fill_1
XFILLER_29_125 VDD VDD VSS VSS gf180mcu_fd_sc_mcu7t5v0__fill_1
Xu_core.delay_paths.u_trc2.gen_inv_stage\[42\].inv u_core.delay_paths.u_trc2.gen_inv_stage\[42\].inv/I
+ u_core.delay_paths.u_trc2.gen_inv_stage\[43\].inv/I VDD VDD VSS VSS gf180mcu_fd_sc_mcu7t5v0__inv_1
Xu_core.delay_paths.u_trc2.gen_inv_stage\[57\].inv u_core.delay_paths.u_trc2.gen_inv_stage\[57\].inv/I
+ u_core.delay_paths.u_trc2.gen_inv_stage\[58\].inv/I VDD VDD VSS VSS gf180mcu_fd_sc_mcu7t5v0__inv_1
XFILLER_25_386 VDD VDD VSS VSS gf180mcu_fd_sc_mcu7t5v0__fill_2
Xhold60 _704_/Q _690_/D VDD VDD VSS VSS gf180mcu_fd_sc_mcu7t5v0__dlyc_1
XFILLER_16_331 VDD VDD VSS VSS gf180mcu_fd_sc_mcu7t5v0__fillcap_4
XFILLER_31_345 VDD VDD VSS VSS gf180mcu_fd_sc_mcu7t5v0__fill_1
X_666_ _666_/D _666_/RN _704_/CLK _666_/Q VDD VDD VSS VSS gf180mcu_fd_sc_mcu7t5v0__dffrnq_1
X_597_ _602_/I _628_/RN VDD VDD VSS VSS gf180mcu_fd_sc_mcu7t5v0__clkinv_1
XTAP_TAPCELL_ROW_33_329 VDD VSS gf180mcu_fd_sc_mcu7t5v0__filltie
XFILLER_6_53 VDD VDD VSS VSS gf180mcu_fd_sc_mcu7t5v0__fillcap_8
XFILLER_22_378 VDD VDD VSS VSS gf180mcu_fd_sc_mcu7t5v0__fillcap_4
X_520_ _622_/Q _437_/Z _527_/A2 VDD VDD VSS VSS gf180mcu_fd_sc_mcu7t5v0__nand2_1
XFILLER_13_345 VDD VDD VSS VSS gf180mcu_fd_sc_mcu7t5v0__fillcap_4
X_451_ _451_/A1 _453_/B _451_/B1 _451_/B2 _631_/D VDD VDD VSS VSS gf180mcu_fd_sc_mcu7t5v0__aoi22_1
X_382_ _682_/Q _380_/Z _384_/A2 VDD VDD VSS VSS gf180mcu_fd_sc_mcu7t5v0__nor2_1
XFILLER_31_72 VDD VDD VSS VSS gf180mcu_fd_sc_mcu7t5v0__fill_2
Xtrc_top_46 oINTERRUPT_PD VDD VDD VSS VSS gf180mcu_fd_sc_mcu7t5v0__tiel
XPHY_EDGE_ROW_33_Left_94 VDD VSS gf180mcu_fd_sc_mcu7t5v0__endcap
XFILLER_0_293 VDD VDD VSS VSS gf180mcu_fd_sc_mcu7t5v0__fillcap_4
X_718_ _718_/I _718_/Z VDD VDD VSS VSS gf180mcu_fd_sc_mcu7t5v0__buf_1
X_649_ _649_/D _687_/RN _688_/CLK _649_/Q VDD VDD VSS VSS gf180mcu_fd_sc_mcu7t5v0__dffrnq_1
XFILLER_16_172 VDD VDD VSS VSS gf180mcu_fd_sc_mcu7t5v0__fill_2
XFILLER_31_142 VDD VDD VSS VSS gf180mcu_fd_sc_mcu7t5v0__fill_1
XFILLER_31_197 VDD VDD VSS VSS gf180mcu_fd_sc_mcu7t5v0__fillcap_8
Xu_core.delay_paths.u_trc1.gen_inv_stage\[81\].inv u_core.delay_paths.u_trc1.gen_inv_stage\[81\].inv/I
+ u_core.delay_paths.u_trc1.gen_inv_stage\[82\].inv/I VDD VDD VSS VSS gf180mcu_fd_sc_mcu7t5v0__inv_1
Xu_core.delay_paths.u_trc1.gen_inv_stage\[96\].inv u_core.delay_paths.u_trc1.gen_inv_stage\[96\].inv/I
+ u_core.delay_paths.u_trc1.gen_inv_stage\[97\].inv/I VDD VDD VSS VSS gf180mcu_fd_sc_mcu7t5v0__inv_1
XFILLER_39_275 VDD VDD VSS VSS gf180mcu_fd_sc_mcu7t5v0__fill_1
XFILLER_42_429 VDD VDD VSS VSS gf180mcu_fd_sc_mcu7t5v0__fill_1
Xu_core.delay_paths.u_trc1.gen_inv_stage\[34\].inv u_core.delay_paths.u_trc1.gen_inv_stage\[34\].inv/I
+ u_core.delay_paths.u_trc1.gen_inv_stage\[35\].inv/I VDD VDD VSS VSS gf180mcu_fd_sc_mcu7t5v0__inv_1
XFILLER_10_337 VDD VDD VSS VSS gf180mcu_fd_sc_mcu7t5v0__fill_1
XFILLER_22_153 VDD VDD VSS VSS gf180mcu_fd_sc_mcu7t5v0__fill_2
Xu_core.delay_paths.u_trc1.gen_inv_stage\[49\].inv u_core.delay_paths.u_trc1.gen_inv_stage\[49\].inv/I
+ u_core.delay_paths.u_trc1.gen_inv_stage\[50\].inv/I VDD VDD VSS VSS gf180mcu_fd_sc_mcu7t5v0__inv_1
XTAP_TAPCELL_ROW_60_490 VDD VSS gf180mcu_fd_sc_mcu7t5v0__filltie
XFILLER_45_212 VDD VDD VSS VSS gf180mcu_fd_sc_mcu7t5v0__fillcap_32
Xclkbuf_4_2__f_iCLK clkbuf_0_iCLK/Z _705_/CLK VDD VDD VSS VSS gf180mcu_fd_sc_mcu7t5v0__clkbuf_16
X_503_ _677_/Q _673_/Q _504_/S _677_/D VDD VDD VSS VSS gf180mcu_fd_sc_mcu7t5v0__mux2_2
XFILLER_13_142 VDD VDD VSS VSS gf180mcu_fd_sc_mcu7t5v0__fill_2
XFILLER_13_186 VDD VDD VSS VSS gf180mcu_fd_sc_mcu7t5v0__fillcap_8
XFILLER_42_71 VDD VDD VSS VSS gf180mcu_fd_sc_mcu7t5v0__fillcap_4
X_434_ _434_/I _434_/ZN VDD VDD VSS VSS gf180mcu_fd_sc_mcu7t5v0__clkinv_1
X_365_ _679_/Q _364_/Z _365_/B _374_/A2 VDD VDD VSS VSS gf180mcu_fd_sc_mcu7t5v0__aoi21_1
X_296_ _705_/Q _343_/A1 VDD VDD VSS VSS gf180mcu_fd_sc_mcu7t5v0__clkinv_1
XFILLER_15_418 VDD VDD VSS VSS gf180mcu_fd_sc_mcu7t5v0__fill_2
Xu_core.delay_paths.u_trc0.gen_inv_stage\[184\].inv u_core.delay_paths.u_trc0.gen_inv_stage\[184\].inv/I
+ u_core.delay_paths.u_trc0.gen_inv_stage\[185\].inv/I VDD VDD VSS VSS gf180mcu_fd_sc_mcu7t5v0__inv_1
XFILLER_10_189 VDD VDD VSS VSS gf180mcu_fd_sc_mcu7t5v0__fill_2
Xu_core.delay_paths.u_trc0.gen_inv_stage\[122\].inv u_core.delay_paths.u_trc0.gen_inv_stage\[122\].inv/I
+ u_core.delay_paths.u_trc0.gen_inv_stage\[123\].inv/I VDD VDD VSS VSS gf180mcu_fd_sc_mcu7t5v0__inv_1
XFILLER_5_2 VDD VDD VSS VSS gf180mcu_fd_sc_mcu7t5v0__fillcap_32
Xu_core.delay_paths.u_trc0.gen_inv_stage\[137\].inv u_core.delay_paths.u_trc0.gen_inv_stage\[137\].inv/I
+ u_core.delay_paths.u_trc0.gen_inv_stage\[138\].inv/I VDD VDD VSS VSS gf180mcu_fd_sc_mcu7t5v0__inv_1
XTAP_TAPCELL_ROW_5_160 VDD VSS gf180mcu_fd_sc_mcu7t5v0__filltie
XFILLER_33_259 VDD VDD VSS VSS gf180mcu_fd_sc_mcu7t5v0__fill_2
XFILLER_58_381 VDD VDD VSS VSS gf180mcu_fd_sc_mcu7t5v0__fillcap_4
XPHY_EDGE_ROW_16_Right_16 VDD VSS gf180mcu_fd_sc_mcu7t5v0__endcap
X_417_ _420_/A1 _420_/A2 _418_/A2 VDD VDD VSS VSS gf180mcu_fd_sc_mcu7t5v0__nor2_1
X_348_ _350_/A2 _344_/Z _704_/Q _349_/A2 VDD VDD VSS VSS gf180mcu_fd_sc_mcu7t5v0__oai21_1
XPHY_EDGE_ROW_25_Right_25 VDD VSS gf180mcu_fd_sc_mcu7t5v0__endcap
XFILLER_38_2 VDD VDD VSS VSS gf180mcu_fd_sc_mcu7t5v0__fillcap_32
Xu_core.delay_paths.u_trc0.gen_inv_stage\[73\].inv u_core.delay_paths.u_trc0.gen_inv_stage\[73\].inv/I
+ u_core.delay_paths.u_trc0.gen_inv_stage\[74\].inv/I VDD VDD VSS VSS gf180mcu_fd_sc_mcu7t5v0__inv_1
XTAP_TAPCELL_ROW_11_195 VDD VSS gf180mcu_fd_sc_mcu7t5v0__filltie
Xu_core.delay_paths.u_trc0.gen_inv_stage\[88\].inv u_core.delay_paths.u_trc0.gen_inv_stage\[88\].inv/I
+ u_core.delay_paths.u_trc0.gen_inv_stage\[89\].inv/I VDD VDD VSS VSS gf180mcu_fd_sc_mcu7t5v0__inv_2
XPHY_EDGE_ROW_34_Right_34 VDD VSS gf180mcu_fd_sc_mcu7t5v0__endcap
XFILLER_24_237 VDD VDD VSS VSS gf180mcu_fd_sc_mcu7t5v0__fillcap_8
XFILLER_24_259 VDD VDD VSS VSS gf180mcu_fd_sc_mcu7t5v0__fill_2
Xu_core.delay_paths.u_trc0.gen_inv_stage\[11\].inv u_core.delay_paths.u_trc0.gen_inv_stage\[11\].inv/I
+ u_core.delay_paths.u_trc0.gen_inv_stage\[12\].inv/I VDD VDD VSS VSS gf180mcu_fd_sc_mcu7t5v0__inv_1
XPHY_EDGE_ROW_20_Left_81 VDD VSS gf180mcu_fd_sc_mcu7t5v0__endcap
Xu_core.delay_paths.u_trc0.gen_inv_stage\[26\].inv u_core.delay_paths.u_trc0.gen_inv_stage\[26\].inv/I
+ u_core.delay_paths.u_trc0.gen_inv_stage\[27\].inv/I VDD VDD VSS VSS gf180mcu_fd_sc_mcu7t5v0__inv_1
XPHY_EDGE_ROW_43_Right_43 VDD VSS gf180mcu_fd_sc_mcu7t5v0__endcap
XFILLER_58_37 VDD VDD VSS VSS gf180mcu_fd_sc_mcu7t5v0__fillcap_64
XPHY_EDGE_ROW_52_Right_52 VDD VSS gf180mcu_fd_sc_mcu7t5v0__endcap
XTAP_TAPCELL_ROW_2_141 VDD VSS gf180mcu_fd_sc_mcu7t5v0__filltie
XFILLER_2_141 VDD VDD VSS VSS gf180mcu_fd_sc_mcu7t5v0__fillcap_4
XFILLER_2_174 VDD VDD VSS VSS gf180mcu_fd_sc_mcu7t5v0__fill_1
XFILLER_0_66 VDD VDD VSS VSS gf180mcu_fd_sc_mcu7t5v0__fill_2
XFILLER_21_207 VDD VDD VSS VSS gf180mcu_fd_sc_mcu7t5v0__fill_2
XFILLER_52_387 VDD VDD VSS VSS gf180mcu_fd_sc_mcu7t5v0__fillcap_32
Xu_core.delay_paths.u_trc0.gen_inv_stage\[3\].inv u_core.delay_paths.u_trc0.gen_inv_stage\[3\].inv/I
+ u_core.delay_paths.u_trc0.gen_inv_stage\[4\].inv/I VDD VDD VSS VSS gf180mcu_fd_sc_mcu7t5v0__inv_1
X_682_ _682_/D _686_/RN _682_/CLK _682_/Q VDD VDD VSS VSS gf180mcu_fd_sc_mcu7t5v0__dffrnq_1
Xu_core.delay_paths.u_trc2.gen_inv_stage\[2\].inv u_core.delay_paths.u_trc2.gen_inv_stage\[2\].inv/I
+ u_core.delay_paths.u_trc2.gen_inv_stage\[3\].inv/I VDD VDD VSS VSS gf180mcu_fd_sc_mcu7t5v0__inv_1
XFILLER_34_343 VDD VDD VSS VSS gf180mcu_fd_sc_mcu7t5v0__fill_1
XFILLER_38_115 VDD VDD VSS VSS gf180mcu_fd_sc_mcu7t5v0__fill_2
XTAP_TAPCELL_ROW_36_349 VDD VSS gf180mcu_fd_sc_mcu7t5v0__filltie
XFILLER_34_387 VDD VDD VSS VSS gf180mcu_fd_sc_mcu7t5v0__fillcap_16
XTAP_TAPCELL_ROW_44_393 VDD VSS gf180mcu_fd_sc_mcu7t5v0__filltie
XPHY_EDGE_ROW_2_Right_2 VDD VSS gf180mcu_fd_sc_mcu7t5v0__endcap
XFILLER_44_107 VDD VDD VSS VSS gf180mcu_fd_sc_mcu7t5v0__fill_1
Xu_core.delay_paths.u_trc3.gen_inv_stage\[17\].inv u_core.delay_paths.u_trc3.gen_inv_stage\[17\].inv/I
+ u_core.delay_paths.u_trc3.gen_inv_stage\[18\].inv/I VDD VDD VSS VSS gf180mcu_fd_sc_mcu7t5v0__inv_1
XFILLER_4_214 VDD VDD VSS VSS gf180mcu_fd_sc_mcu7t5v0__fillcap_16
XFILLER_20_85 VDD VDD VSS VSS gf180mcu_fd_sc_mcu7t5v0__fillcap_8
XPHY_EDGE_ROW_42_Left_103 VDD VSS gf180mcu_fd_sc_mcu7t5v0__endcap
XFILLER_28_181 VDD VDD VSS VSS gf180mcu_fd_sc_mcu7t5v0__fill_2
XFILLER_29_94 VDD VDD VSS VSS gf180mcu_fd_sc_mcu7t5v0__fill_1
Xhold61 _680_/Q hold61/Z VDD VDD VSS VSS gf180mcu_fd_sc_mcu7t5v0__dlyc_1
X_665_ _665_/D _700_/RN _665_/CLK _665_/Q VDD VDD VSS VSS gf180mcu_fd_sc_mcu7t5v0__dffrnq_1
XFILLER_16_387 VDD VDD VSS VSS gf180mcu_fd_sc_mcu7t5v0__fill_1
X_596_ _602_/I _627_/RN VDD VDD VSS VSS gf180mcu_fd_sc_mcu7t5v0__clkinv_1
XTAP_TAPCELL_ROW_41_374 VDD VSS gf180mcu_fd_sc_mcu7t5v0__filltie
XPHY_EDGE_ROW_51_Left_112 VDD VSS gf180mcu_fd_sc_mcu7t5v0__endcap
XPHY_EDGE_ROW_60_Left_121 VDD VSS gf180mcu_fd_sc_mcu7t5v0__endcap
XFILLER_20_2 VDD VDD VSS VSS gf180mcu_fd_sc_mcu7t5v0__fillcap_32
XFILLER_54_427 VDD VDD VSS VSS gf180mcu_fd_sc_mcu7t5v0__fill_2
XFILLER_22_357 VDD VDD VSS VSS gf180mcu_fd_sc_mcu7t5v0__fillcap_4
XFILLER_45_416 VDD VDD VSS VSS gf180mcu_fd_sc_mcu7t5v0__fillcap_4
XFILLER_57_276 VDD VDD VSS VSS gf180mcu_fd_sc_mcu7t5v0__fillcap_4
XFILLER_13_302 VDD VDD VSS VSS gf180mcu_fd_sc_mcu7t5v0__fillcap_8
XFILLER_40_121 VDD VDD VSS VSS gf180mcu_fd_sc_mcu7t5v0__fillcap_4
X_450_ _638_/Q _437_/Z _535_/A2 _649_/Q _451_/B2 VDD VDD VSS VSS gf180mcu_fd_sc_mcu7t5v0__aoi22_1
X_381_ _682_/Q _380_/Z _384_/B VDD VDD VSS VSS gf180mcu_fd_sc_mcu7t5v0__nand2_1
XFILLER_31_84 VDD VDD VSS VSS gf180mcu_fd_sc_mcu7t5v0__fillcap_8
Xtrc_top_47 oINTERRUPT_PU VDD VDD VSS VSS gf180mcu_fd_sc_mcu7t5v0__tiel
Xoutput5 _354_/Z wire7/I VDD VDD VSS VSS gf180mcu_fd_sc_mcu7t5v0__buf_1
XFILLER_36_427 VDD VDD VSS VSS gf180mcu_fd_sc_mcu7t5v0__fill_2
X_648_ _648_/D _695_/RN _695_/CLK _648_/Q VDD VDD VSS VSS gf180mcu_fd_sc_mcu7t5v0__dffrnq_1
XFILLER_8_361 VDD VDD VSS VSS gf180mcu_fd_sc_mcu7t5v0__fill_1
Xu_core.delay_paths.u_trc2.gen_inv_stage\[41\].inv u_core.delay_paths.u_trc2.gen_inv_stage\[41\].inv/I
+ u_core.delay_paths.u_trc2.gen_inv_stage\[42\].inv/I VDD VDD VSS VSS gf180mcu_fd_sc_mcu7t5v0__inv_1
X_579_ _579_/A1 _584_/B2 _579_/B1 _579_/B2 _660_/D VDD VDD VSS VSS gf180mcu_fd_sc_mcu7t5v0__aoi22_1
Xu_core.delay_paths.u_trc2.gen_inv_stage\[56\].inv u_core.delay_paths.u_trc2.gen_inv_stage\[56\].inv/I
+ u_core.delay_paths.u_trc2.gen_inv_stage\[57\].inv/I VDD VDD VSS VSS gf180mcu_fd_sc_mcu7t5v0__inv_1
XFILLER_27_416 VDD VDD VSS VSS gf180mcu_fd_sc_mcu7t5v0__fillcap_4
XFILLER_42_419 VDD VDD VSS VSS gf180mcu_fd_sc_mcu7t5v0__fillcap_8
XTAP_TAPCELL_ROW_60_491 VDD VSS gf180mcu_fd_sc_mcu7t5v0__filltie
XFILLER_33_419 VDD VDD VSS VSS gf180mcu_fd_sc_mcu7t5v0__fill_1
XFILLER_45_202 VDD VDD VSS VSS gf180mcu_fd_sc_mcu7t5v0__fill_1
XFILLER_45_268 VDD VDD VSS VSS gf180mcu_fd_sc_mcu7t5v0__fillcap_8
X_502_ _676_/Q _672_/Q _515_/S _676_/D VDD VDD VSS VSS gf180mcu_fd_sc_mcu7t5v0__mux2_2
X_433_ _624_/Q _623_/Q _625_/Q _633_/Q _434_/I VDD VDD VSS VSS gf180mcu_fd_sc_mcu7t5v0__oai31_1
XFILLER_13_198 VDD VDD VSS VSS gf180mcu_fd_sc_mcu7t5v0__fill_2
X_364_ _675_/Q _671_/Q _364_/Z VDD VDD VSS VSS gf180mcu_fd_sc_mcu7t5v0__xor2_1
Xu_core.delay_paths.u_trc1.gen_inv_stage\[143\].inv u_core.delay_paths.u_trc1.gen_inv_stage\[143\].inv/I
+ _721_/I VDD VDD VSS VSS gf180mcu_fd_sc_mcu7t5v0__inv_1
XFILLER_3_66 VDD VDD VSS VSS gf180mcu_fd_sc_mcu7t5v0__fillcap_4
Xwire17 _390_/Z wire17/Z VDD VDD VSS VSS gf180mcu_fd_sc_mcu7t5v0__clkbuf_2
XTAP_TAPCELL_ROW_8_180 VDD VSS gf180mcu_fd_sc_mcu7t5v0__filltie
Xwire28 wire28/I wire28/Z VDD VDD VSS VSS gf180mcu_fd_sc_mcu7t5v0__buf_3
XFILLER_42_249 VDD VDD VSS VSS gf180mcu_fd_sc_mcu7t5v0__fill_1
Xu_core.delay_paths.u_trc1.gen_inv_stage\[80\].inv u_core.delay_paths.u_trc1.gen_inv_stage\[80\].inv/I
+ u_core.delay_paths.u_trc1.gen_inv_stage\[81\].inv/I VDD VDD VSS VSS gf180mcu_fd_sc_mcu7t5v0__inv_1
XTAP_TAPCELL_ROW_5_161 VDD VSS gf180mcu_fd_sc_mcu7t5v0__filltie
XFILLER_37_72 VDD VDD VSS VSS gf180mcu_fd_sc_mcu7t5v0__fill_2
Xu_core.delay_paths.u_trc1.gen_inv_stage\[95\].inv u_core.delay_paths.u_trc1.gen_inv_stage\[95\].inv/I
+ u_core.delay_paths.u_trc1.gen_inv_stage\[96\].inv/I VDD VDD VSS VSS gf180mcu_fd_sc_mcu7t5v0__inv_1
X_416_ _416_/A1 _396_/Z _416_/B1 _416_/B2 _420_/A4 VDD VDD VSS VSS gf180mcu_fd_sc_mcu7t5v0__oai22_1
XTAP_TAPCELL_ROW_28_296 VDD VSS gf180mcu_fd_sc_mcu7t5v0__filltie
XFILLER_41_271 VDD VDD VSS VSS gf180mcu_fd_sc_mcu7t5v0__fill_2
X_347_ _704_/Q _350_/A2 _344_/Z _347_/B _349_/A1 VDD VDD VSS VSS gf180mcu_fd_sc_mcu7t5v0__oai31_1
XTAP_TAPCELL_ROW_11_196 VDD VSS gf180mcu_fd_sc_mcu7t5v0__filltie
Xu_core.delay_paths.u_trc1.gen_inv_stage\[33\].inv u_core.delay_paths.u_trc1.gen_inv_stage\[33\].inv/I
+ u_core.delay_paths.u_trc1.gen_inv_stage\[34\].inv/I VDD VDD VSS VSS gf180mcu_fd_sc_mcu7t5v0__inv_1
Xu_core.delay_paths.u_trc1.gen_inv_stage\[48\].inv u_core.delay_paths.u_trc1.gen_inv_stage\[48\].inv/I
+ u_core.delay_paths.u_trc1.gen_inv_stage\[49\].inv/I VDD VDD VSS VSS gf180mcu_fd_sc_mcu7t5v0__inv_1
XFILLER_55_352 VDD VDD VSS VSS gf180mcu_fd_sc_mcu7t5v0__fillcap_64
XTAP_TAPCELL_ROW_2_142 VDD VSS gf180mcu_fd_sc_mcu7t5v0__filltie
XFILLER_11_422 VDD VDD VSS VSS gf180mcu_fd_sc_mcu7t5v0__fillcap_8
XFILLER_23_260 VDD VDD VSS VSS gf180mcu_fd_sc_mcu7t5v0__fillcap_4
XFILLER_23_282 VDD VDD VSS VSS gf180mcu_fd_sc_mcu7t5v0__fillcap_4
XFILLER_48_93 VDD VDD VSS VSS gf180mcu_fd_sc_mcu7t5v0__fillcap_8
XFILLER_0_89 VDD VDD VSS VSS gf180mcu_fd_sc_mcu7t5v0__fill_1
XFILLER_50_2 VDD VDD VSS VSS gf180mcu_fd_sc_mcu7t5v0__fillcap_32
Xu_core.delay_paths.u_trc0.gen_inv_stage\[183\].inv u_core.delay_paths.u_trc0.gen_inv_stage\[183\].inv/I
+ u_core.delay_paths.u_trc0.gen_inv_stage\[184\].inv/I VDD VDD VSS VSS gf180mcu_fd_sc_mcu7t5v0__inv_1
XFILLER_37_352 VDD VDD VSS VSS gf180mcu_fd_sc_mcu7t5v0__fillcap_64
XFILLER_52_311 VDD VDD VSS VSS gf180mcu_fd_sc_mcu7t5v0__fillcap_4
Xu_core.delay_paths.u_trc0.gen_inv_stage\[121\].inv u_core.delay_paths.u_trc0.gen_inv_stage\[121\].inv/I
+ u_core.delay_paths.u_trc0.gen_inv_stage\[122\].inv/I VDD VDD VSS VSS gf180mcu_fd_sc_mcu7t5v0__inv_1
XFILLER_20_263 VDD VDD VSS VSS gf180mcu_fd_sc_mcu7t5v0__fillcap_8
XFILLER_4_407 VDD VDD VSS VSS gf180mcu_fd_sc_mcu7t5v0__fillcap_4
XFILLER_60_17 VDD VDD VSS VSS gf180mcu_fd_sc_mcu7t5v0__fillcap_16
Xu_core.delay_paths.u_trc0.gen_inv_stage\[136\].inv u_core.delay_paths.u_trc0.gen_inv_stage\[136\].inv/I
+ u_core.delay_paths.u_trc0.gen_inv_stage\[137\].inv/I VDD VDD VSS VSS gf180mcu_fd_sc_mcu7t5v0__inv_1
XFILLER_43_300 VDD VDD VSS VSS gf180mcu_fd_sc_mcu7t5v0__fill_1
X_681_ _681_/D _685_/RN _685_/CLK _681_/Q VDD VDD VSS VSS gf180mcu_fd_sc_mcu7t5v0__dffrnq_1
Xu_core.delay_paths.u_trc0.gen_inv_stage\[72\].inv u_core.delay_paths.u_trc0.gen_inv_stage\[72\].inv/I
+ u_core.delay_paths.u_trc0.gen_inv_stage\[73\].inv/I VDD VDD VSS VSS gf180mcu_fd_sc_mcu7t5v0__inv_1
XFILLER_7_212 VDD VDD VSS VSS gf180mcu_fd_sc_mcu7t5v0__fillcap_8
Xu_core.delay_paths.u_trc0.gen_inv_stage\[87\].inv u_core.delay_paths.u_trc0.gen_inv_stage\[87\].inv/I
+ u_core.delay_paths.u_trc0.gen_inv_stage\[88\].inv/I VDD VDD VSS VSS gf180mcu_fd_sc_mcu7t5v0__inv_2
Xu_core.delay_paths.u_trc0.gen_inv_stage\[10\].inv u_core.delay_paths.u_trc0.gen_inv_stage\[9\].inv/ZN
+ u_core.delay_paths.u_trc0.gen_inv_stage\[11\].inv/I VDD VDD VSS VSS gf180mcu_fd_sc_mcu7t5v0__inv_1
XFILLER_19_352 VDD VDD VSS VSS gf180mcu_fd_sc_mcu7t5v0__fill_2
XFILLER_46_193 VDD VDD VSS VSS gf180mcu_fd_sc_mcu7t5v0__fillcap_8
Xu_core.delay_paths.u_trc0.gen_inv_stage\[25\].inv u_core.delay_paths.u_trc0.gen_inv_stage\[25\].inv/I
+ u_core.delay_paths.u_trc0.gen_inv_stage\[26\].inv/I VDD VDD VSS VSS gf180mcu_fd_sc_mcu7t5v0__inv_1
XTAP_TAPCELL_ROW_44_394 VDD VSS gf180mcu_fd_sc_mcu7t5v0__filltie
XFILLER_39_18 VDD VDD VSS VSS gf180mcu_fd_sc_mcu7t5v0__fillcap_8
XFILLER_29_105 VDD VDD VSS VSS gf180mcu_fd_sc_mcu7t5v0__fillcap_16
XFILLER_40_303 VDD VDD VSS VSS gf180mcu_fd_sc_mcu7t5v0__fillcap_8
XFILLER_40_369 VDD VDD VSS VSS gf180mcu_fd_sc_mcu7t5v0__fillcap_16
XFILLER_0_410 VDD VDD VSS VSS gf180mcu_fd_sc_mcu7t5v0__fillcap_16
XFILLER_28_160 VDD VDD VSS VSS gf180mcu_fd_sc_mcu7t5v0__fillcap_8
Xhold62 _662_/Q _316_/I VDD VDD VSS VSS gf180mcu_fd_sc_mcu7t5v0__dlyc_1
X_664_ _664_/D _666_/RN _700_/CLK _664_/Q VDD VDD VSS VSS gf180mcu_fd_sc_mcu7t5v0__dffrnq_1
X_595_ _601_/I _626_/RN VDD VDD VSS VSS gf180mcu_fd_sc_mcu7t5v0__clkinv_1
XTAP_TAPCELL_ROW_41_375 VDD VSS gf180mcu_fd_sc_mcu7t5v0__filltie
XFILLER_6_66 VDD VDD VSS VSS gf180mcu_fd_sc_mcu7t5v0__fillcap_8
XFILLER_13_2 VDD VDD VSS VSS gf180mcu_fd_sc_mcu7t5v0__fillcap_64
XFILLER_22_325 VDD VDD VSS VSS gf180mcu_fd_sc_mcu7t5v0__fill_1
Xu_core.delay_paths.u_trc0.gen_inv_stage\[2\].inv u_core.delay_paths.u_trc0.gen_inv_stage\[2\].inv/I
+ u_core.delay_paths.u_trc0.gen_inv_stage\[3\].inv/I VDD VDD VSS VSS gf180mcu_fd_sc_mcu7t5v0__inv_1
XTAP_TAPCELL_ROW_32_320 VDD VSS gf180mcu_fd_sc_mcu7t5v0__filltie
Xu_core.delay_paths.u_trc2.gen_inv_stage\[1\].inv u_core.delay_paths.u_trc2.gen_inv_stage\[1\].inv/I
+ u_core.delay_paths.u_trc2.gen_inv_stage\[2\].inv/I VDD VDD VSS VSS gf180mcu_fd_sc_mcu7t5v0__inv_1
XFILLER_40_133 VDD VDD VSS VSS gf180mcu_fd_sc_mcu7t5v0__fillcap_8
XFILLER_40_177 VDD VDD VSS VSS gf180mcu_fd_sc_mcu7t5v0__fillcap_8
X_380_ _678_/Q _674_/Q _380_/Z VDD VDD VSS VSS gf180mcu_fd_sc_mcu7t5v0__xor2_1
XFILLER_31_74 VDD VDD VSS VSS gf180mcu_fd_sc_mcu7t5v0__fill_1
XFILLER_31_96 VDD VDD VSS VSS gf180mcu_fd_sc_mcu7t5v0__fill_1
Xtrc_top_48 oINTERRUPT_SL VDD VDD VSS VSS gf180mcu_fd_sc_mcu7t5v0__tiel
Xoutput6 _434_/ZN wire11/I VDD VDD VSS VSS gf180mcu_fd_sc_mcu7t5v0__buf_1
XFILLER_0_240 VDD VDD VSS VSS gf180mcu_fd_sc_mcu7t5v0__fillcap_32
XFILLER_16_174 VDD VDD VSS VSS gf180mcu_fd_sc_mcu7t5v0__fill_1
XFILLER_16_185 VDD VDD VSS VSS gf180mcu_fd_sc_mcu7t5v0__fill_2
X_647_ _647_/D _695_/RN _692_/CLK _647_/Q VDD VDD VSS VSS gf180mcu_fd_sc_mcu7t5v0__dffsnq_1
X_578_ _584_/B2 _578_/A2 _579_/B2 VDD VDD VSS VSS gf180mcu_fd_sc_mcu7t5v0__nor2_1
Xu_core.delay_paths.u_trc3.gen_inv_stage\[16\].inv u_core.delay_paths.u_trc3.gen_inv_stage\[16\].inv/I
+ u_core.delay_paths.u_trc3.gen_inv_stage\[17\].inv/I VDD VDD VSS VSS gf180mcu_fd_sc_mcu7t5v0__inv_1
.ends
